* BEGIN ANSOFT HEADER
* node 1    A-MII-RXD1_30_SQFP28X28_208_U1
* node 2    A-MII-RXD1_65_SQFP20X20_144_U7
* node 3    A-MII-RXD2_32_SQFP28X28_208_U1
* node 4    A-MII-RXD2_66_SQFP20X20_144_U7
* node 5    A-MII-RXD3_33_SQFP28X28_208_U1
* node 6    A-MII-RXD3_67_SQFP20X20_144_U7
*    Setup: SSN_1.5_ssn
*   Format: HSPICE
*   Topckt: SSN_1_5_ssn_sp
*     Date: Tue May 05 09:41:39 2026
*    Notes: Model produced by Ansys Electronics Desktop 2026 R1
*         : Frequency range: 0 to 1e+10 Hz, 362 points
*         : Maximum number of poles: 10000
*         : S-Matrix fitting error tolerance: 0.005
*         : Causality check tolerance: 0.01
*         : Passivity enforcement: off
*         : Causality enforcement: off
*         : Fitting method: FastFit
*         : Matrix fitting: By entire matrix (required by FastFit)
*         : Ensure Z-parameter accuracy: on
*         : Relative error control: off
*         : Ground reference option: none
*         : Final fitting error: 0.00398596
*         : Final model order: 900
* END ANSOFT HEADER

.subckt SSN_1_5_ssn_sp 1 2 3 4 5 6
Vam1 1 n2 dc 0
Rport1 n2 0 50 noise=0
Vam2 2 n4 dc 0
Rport2 n4 0 50 noise=0
Vam3 3 n6 dc 0
Rport3 n6 0 50 noise=0
Vam4 4 n8 dc 0
Rport4 n8 0 50 noise=0
Vam5 5 n10 dc 0
Rport5 n10 0 50 noise=0
Vam6 6 n12 dc 0
Rport6 n12 0 50 noise=0

Fi1 0 ni1 Vam1 50
Gi1 0 ni1 1 0 1
Rt1 ni1 0 1 noise=0
Fi2 0 ni2 Vam2 50
Gi2 0 ni2 2 0 1
Rt2 ni2 0 1 noise=0
Fi3 0 ni3 Vam3 50
Gi3 0 ni3 3 0 1
Rt3 ni3 0 1 noise=0
Fi4 0 ni4 Vam4 50
Gi4 0 ni4 4 0 1
Rt4 ni4 0 1 noise=0
Fi5 0 ni5 Vam5 50
Gi5 0 ni5 5 0 1
Rt5 ni5 0 1 noise=0
Fi6 0 ni6 Vam6 50
Gi6 0 ni6 6 0 1
Rt6 ni6 0 1 noise=0

Ca1 ns1 0 1e-12
Ca2 ns2 0 1e-12
Ra1 ns1 0 8.25083067625 noise=0
Ra2 ns2 0 8.25083067625 noise=0
Ga1 ns1 0 ns2 0 -0.0427893075299
Ga2 ns2 0 ns1 0 0.0427893075299
Ca3 ns3 0 1e-12
Ca4 ns4 0 1e-12
Ra3 ns3 0 106.169491387 noise=0
Ra4 ns4 0 106.169491387 noise=0
Ga3 ns3 0 ns4 0 -0.0711386311877
Ga4 ns4 0 ns3 0 0.0711386311877
Ca5 ns5 0 1e-12
Ca6 ns6 0 1e-12
Ra5 ns5 0 714.164477404 noise=0
Ra6 ns6 0 714.164477404 noise=0
Ga5 ns5 0 ns6 0 -0.0649673770601
Ga6 ns6 0 ns5 0 0.0649673770601
Ca7 ns7 0 1e-12
Ca8 ns8 0 1e-12
Ra7 ns7 0 659.637590341 noise=0
Ra8 ns8 0 659.637590341 noise=0
Ga7 ns7 0 ns8 0 -0.0625850853995
Ga8 ns8 0 ns7 0 0.0625850853995
Ca9 ns9 0 1e-12
Ca10 ns10 0 1e-12
Ra9 ns9 0 27454.0019815 noise=0
Ra10 ns10 0 27454.0019815 noise=0
Ga9 ns9 0 ns10 0 -0.0617049463428
Ga10 ns10 0 ns9 0 0.0617049463428
Ca11 ns11 0 1e-12
Ca12 ns12 0 1e-12
Ra11 ns11 0 696.676751258 noise=0
Ra12 ns12 0 696.676751258 noise=0
Ga11 ns11 0 ns12 0 -0.0610299670021
Ga12 ns12 0 ns11 0 0.0610299670021
Ca13 ns13 0 1e-12
Ca14 ns14 0 1e-12
Ra13 ns13 0 944.255939097 noise=0
Ra14 ns14 0 944.255939097 noise=0
Ga13 ns13 0 ns14 0 -0.0596057773168
Ga14 ns14 0 ns13 0 0.0596057773168
Ca15 ns15 0 1e-12
Ca16 ns16 0 1e-12
Ra15 ns15 0 792.645910493 noise=0
Ra16 ns16 0 792.645910493 noise=0
Ga15 ns15 0 ns16 0 -0.0587366995705
Ga16 ns16 0 ns15 0 0.0587366995705
Ca17 ns17 0 1e-12
Ca18 ns18 0 1e-12
Ra17 ns17 0 667.745443679 noise=0
Ra18 ns18 0 667.745443679 noise=0
Ga17 ns17 0 ns18 0 -0.0571177908626
Ga18 ns18 0 ns17 0 0.0571177908626
Ca19 ns19 0 1e-12
Ca20 ns20 0 1e-12
Ra19 ns19 0 683.486879096 noise=0
Ra20 ns20 0 683.486879096 noise=0
Ga19 ns19 0 ns20 0 -0.0551711926529
Ga20 ns20 0 ns19 0 0.0551711926529
Ca21 ns21 0 1e-12
Ca22 ns22 0 1e-12
Ra21 ns21 0 862.471199603 noise=0
Ra22 ns22 0 862.471199603 noise=0
Ga21 ns21 0 ns22 0 -0.0543880261285
Ga22 ns22 0 ns21 0 0.0543880261285
Ca23 ns23 0 1e-12
Ca24 ns24 0 1e-12
Ra23 ns23 0 529.094552392 noise=0
Ra24 ns24 0 529.094552392 noise=0
Ga23 ns23 0 ns24 0 -0.0521921809837
Ga24 ns24 0 ns23 0 0.0521921809837
Ca25 ns25 0 1e-12
Ca26 ns26 0 1e-12
Ra25 ns25 0 1662.50489913 noise=0
Ra26 ns26 0 1662.50489913 noise=0
Ga25 ns25 0 ns26 0 -0.0518326775062
Ga26 ns26 0 ns25 0 0.0518326775062
Ca27 ns27 0 1e-12
Ca28 ns28 0 1e-12
Ra27 ns27 0 823.283626698 noise=0
Ra28 ns28 0 823.283626698 noise=0
Ga27 ns27 0 ns28 0 -0.0503365541484
Ga28 ns28 0 ns27 0 0.0503365541484
Ca29 ns29 0 1e-12
Ca30 ns30 0 1e-12
Ra29 ns29 0 498.747250885 noise=0
Ra30 ns30 0 498.747250885 noise=0
Ga29 ns29 0 ns30 0 -0.0480660213561
Ga30 ns30 0 ns29 0 0.0480660213561
Ca31 ns31 0 1e-12
Ca32 ns32 0 1e-12
Ra31 ns31 0 2400.34571746 noise=0
Ra32 ns32 0 2400.34571746 noise=0
Ga31 ns31 0 ns32 0 -0.0491541733443
Ga32 ns32 0 ns31 0 0.0491541733443
Ca33 ns33 0 1e-12
Ca34 ns34 0 1e-12
Ra33 ns33 0 1789.73820066 noise=0
Ra34 ns34 0 1789.73820066 noise=0
Ga33 ns33 0 ns34 0 -0.0472980535656
Ga34 ns34 0 ns33 0 0.0472980535656
Ca35 ns35 0 1e-12
Ca36 ns36 0 1e-12
Ra35 ns35 0 619.467180392 noise=0
Ra36 ns36 0 619.467180392 noise=0
Ga35 ns35 0 ns36 0 -0.0454172104854
Ga36 ns36 0 ns35 0 0.0454172104854
Ca37 ns37 0 1e-12
Ca38 ns38 0 1e-12
Ra37 ns37 0 1515.47634345 noise=0
Ra38 ns38 0 1515.47634345 noise=0
Ga37 ns37 0 ns38 0 -0.045410084729
Ga38 ns38 0 ns37 0 0.045410084729
Ca39 ns39 0 1e-12
Ca40 ns40 0 1e-12
Ra39 ns39 0 1056.49405077 noise=0
Ra40 ns40 0 1056.49405077 noise=0
Ga39 ns39 0 ns40 0 -0.04352518111
Ga40 ns40 0 ns39 0 0.04352518111
Ca41 ns41 0 1e-12
Ca42 ns42 0 1e-12
Ra41 ns41 0 584.380114574 noise=0
Ra42 ns42 0 584.380114574 noise=0
Ga41 ns41 0 ns42 0 -0.0420110127096
Ga42 ns42 0 ns41 0 0.0420110127096
Ca43 ns43 0 1e-12
Ca44 ns44 0 1e-12
Ra43 ns43 0 1100.37898121 noise=0
Ra44 ns44 0 1100.37898121 noise=0
Ga43 ns43 0 ns44 0 -0.0421057924028
Ga44 ns44 0 ns43 0 0.0421057924028
Ca45 ns45 0 1e-12
Ca46 ns46 0 1e-12
Ra45 ns45 0 2151.05522891 noise=0
Ra46 ns46 0 2151.05522891 noise=0
Ga45 ns45 0 ns46 0 -0.0411613399603
Ga46 ns46 0 ns45 0 0.0411613399603
Ca47 ns47 0 1e-12
Ca48 ns48 0 1e-12
Ra47 ns47 0 925.931226012 noise=0
Ra48 ns48 0 925.931226012 noise=0
Ga47 ns47 0 ns48 0 -0.0394771715126
Ga48 ns48 0 ns47 0 0.0394771715126
Ca49 ns49 0 1e-12
Ca50 ns50 0 1e-12
Ra49 ns49 0 1418.8089157 noise=0
Ra50 ns50 0 1418.8089157 noise=0
Ga49 ns49 0 ns50 0 -0.0387605133287
Ga50 ns50 0 ns49 0 0.0387605133287
Ca51 ns51 0 1e-12
Ca52 ns52 0 1e-12
Ra51 ns51 0 915.223062825 noise=0
Ra52 ns52 0 915.223062825 noise=0
Ga51 ns51 0 ns52 0 -0.0375772253735
Ga52 ns52 0 ns51 0 0.0375772253735
Ca53 ns53 0 1e-12
Ca54 ns54 0 1e-12
Ra53 ns53 0 840.127812543 noise=0
Ra54 ns54 0 840.127812543 noise=0
Ga53 ns53 0 ns54 0 -0.0364938165135
Ga54 ns54 0 ns53 0 0.0364938165135
Ca55 ns55 0 1e-12
Ca56 ns56 0 1e-12
Ra55 ns55 0 652.300622951 noise=0
Ra56 ns56 0 652.300622951 noise=0
Ga55 ns55 0 ns56 0 -0.0345758138052
Ga56 ns56 0 ns55 0 0.0345758138052
Ca57 ns57 0 1e-12
Ca58 ns58 0 1e-12
Ra57 ns57 0 1514.05417225 noise=0
Ra58 ns58 0 1514.05417225 noise=0
Ga57 ns57 0 ns58 0 -0.0349101368215
Ga58 ns58 0 ns57 0 0.0349101368215
Ca59 ns59 0 1e-12
Ca60 ns60 0 1e-12
Ra59 ns59 0 2090.57622699 noise=0
Ra60 ns60 0 2090.57622699 noise=0
Ga59 ns59 0 ns60 0 -0.0330272390634
Ga60 ns60 0 ns59 0 0.0330272390634
Ca61 ns61 0 1e-12
Ca62 ns62 0 1e-12
Ra61 ns61 0 1332.31293014 noise=0
Ra62 ns62 0 1332.31293014 noise=0
Ga61 ns61 0 ns62 0 -0.0327912251637
Ga62 ns62 0 ns61 0 0.0327912251637
Ca63 ns63 0 1e-12
Ca64 ns64 0 1e-12
Ra63 ns63 0 562.450005592 noise=0
Ra64 ns64 0 562.450005592 noise=0
Ga63 ns63 0 ns64 0 -0.031824332533
Ga64 ns64 0 ns63 0 0.031824332533
Ca65 ns65 0 1e-12
Ca66 ns66 0 1e-12
Ra65 ns65 0 2569.70403351 noise=0
Ra66 ns66 0 2569.70403351 noise=0
Ga65 ns65 0 ns66 0 -0.0308554267187
Ga66 ns66 0 ns65 0 0.0308554267187
Ca67 ns67 0 1e-12
Ca68 ns68 0 1e-12
Ra67 ns67 0 1611.59888007 noise=0
Ra68 ns68 0 1611.59888007 noise=0
Ga67 ns67 0 ns68 0 -0.0300762531925
Ga68 ns68 0 ns67 0 0.0300762531925
Ca69 ns69 0 1e-12
Ca70 ns70 0 1e-12
Ra69 ns69 0 9772.30555598 noise=0
Ra70 ns70 0 9772.30555598 noise=0
Ga69 ns69 0 ns70 0 -0.0293102987233
Ga70 ns70 0 ns69 0 0.0293102987233
Ca71 ns71 0 1e-12
Ca72 ns72 0 1e-12
Ra71 ns71 0 719.606922067 noise=0
Ra72 ns72 0 719.606922067 noise=0
Ga71 ns71 0 ns72 0 -0.027902812344
Ga72 ns72 0 ns71 0 0.027902812344
Ca73 ns73 0 1e-12
Ca74 ns74 0 1e-12
Ra73 ns73 0 868.71266533 noise=0
Ra74 ns74 0 868.71266533 noise=0
Ga73 ns73 0 ns74 0 -0.027105710132
Ga74 ns74 0 ns73 0 0.027105710132
Ca75 ns75 0 1e-12
Ca76 ns76 0 1e-12
Ra75 ns75 0 2839.48624926 noise=0
Ra76 ns76 0 2839.48624926 noise=0
Ga75 ns75 0 ns76 0 -0.0273663668076
Ga76 ns76 0 ns75 0 0.0273663668076
Ca77 ns77 0 1e-12
Ca78 ns78 0 1e-12
Ra77 ns77 0 1673.32761037 noise=0
Ra78 ns78 0 1673.32761037 noise=0
Ga77 ns77 0 ns78 0 -0.0258400591067
Ga78 ns78 0 ns77 0 0.0258400591067
Ca79 ns79 0 1e-12
Ca80 ns80 0 1e-12
Ra79 ns79 0 1484.37908566 noise=0
Ra80 ns80 0 1484.37908566 noise=0
Ga79 ns79 0 ns80 0 -0.025495699249
Ga80 ns80 0 ns79 0 0.025495699249
Ca81 ns81 0 1e-12
Ca82 ns82 0 1e-12
Ra81 ns81 0 506.028775389 noise=0
Ra82 ns82 0 506.028775389 noise=0
Ga81 ns81 0 ns82 0 -0.0244848458169
Ga82 ns82 0 ns81 0 0.0244848458169
Ca83 ns83 0 1e-12
Ca84 ns84 0 1e-12
Ra83 ns83 0 2403.73305872 noise=0
Ra84 ns84 0 2403.73305872 noise=0
Ga83 ns83 0 ns84 0 -0.0239731392386
Ga84 ns84 0 ns83 0 0.0239731392386
Ca85 ns85 0 1e-12
Ca86 ns86 0 1e-12
Ra85 ns85 0 336.720349191 noise=0
Ra86 ns86 0 336.720349191 noise=0
Ga85 ns85 0 ns86 0 -0.00305921925757
Ga86 ns86 0 ns85 0 0.00305921925757
Ca87 ns87 0 1e-12
Ra87 ns87 0 625.504211572 noise=0
Ca88 ns88 0 1e-12
Ca89 ns89 0 1e-12
Ra88 ns88 0 430.146675815 noise=0
Ra89 ns89 0 430.146675815 noise=0
Ga88 ns88 0 ns89 0 -0.00415320581989
Ga89 ns89 0 ns88 0 0.00415320581989
Ca90 ns90 0 1e-12
Ra90 ns90 0 17951.6203469 noise=0
Ca91 ns91 0 1e-12
Ca92 ns92 0 1e-12
Ra91 ns91 0 2821.37654478 noise=0
Ra92 ns92 0 2821.37654478 noise=0
Ga91 ns91 0 ns92 0 -0.0232374996199
Ga92 ns92 0 ns91 0 0.0232374996199
Ca93 ns93 0 1e-12
Ca94 ns94 0 1e-12
Ra93 ns93 0 67461.356792 noise=0
Ra94 ns94 0 67461.356792 noise=0
Ga93 ns93 0 ns94 0 -0.0231359324144
Ga94 ns94 0 ns93 0 0.0231359324144
Ca95 ns95 0 1e-12
Ca96 ns96 0 1e-12
Ra95 ns95 0 3882.52713252 noise=0
Ra96 ns96 0 3882.52713252 noise=0
Ga95 ns95 0 ns96 0 -0.0222270795019
Ga96 ns96 0 ns95 0 0.0222270795019
Ca97 ns97 0 1e-12
Ca98 ns98 0 1e-12
Ra97 ns97 0 758.263705618 noise=0
Ra98 ns98 0 758.263705618 noise=0
Ga97 ns97 0 ns98 0 -0.0209094247609
Ga98 ns98 0 ns97 0 0.0209094247609
Ca99 ns99 0 1e-12
Ca100 ns100 0 1e-12
Ra99 ns99 0 8350.80403723 noise=0
Ra100 ns100 0 8350.80403723 noise=0
Ga99 ns99 0 ns100 0 -0.0213852085752
Ga100 ns100 0 ns99 0 0.0213852085752
Ca101 ns101 0 1e-12
Ca102 ns102 0 1e-12
Ra101 ns101 0 616.174027864 noise=0
Ra102 ns102 0 616.174027864 noise=0
Ga101 ns101 0 ns102 0 -0.00740609272703
Ga102 ns102 0 ns101 0 0.00740609272703
Ca103 ns103 0 1e-12
Ca104 ns104 0 1e-12
Ra103 ns103 0 2240.8902644 noise=0
Ra104 ns104 0 2240.8902644 noise=0
Ga103 ns103 0 ns104 0 -0.00746772306658
Ga104 ns104 0 ns103 0 0.00746772306658
Ca105 ns105 0 1e-12
Ca106 ns106 0 1e-12
Ra105 ns105 0 1715.78726301 noise=0
Ra106 ns106 0 1715.78726301 noise=0
Ga105 ns105 0 ns106 0 -0.0202800924869
Ga106 ns106 0 ns105 0 0.0202800924869
Ca107 ns107 0 1e-12
Ca108 ns108 0 1e-12
Ra107 ns107 0 408.27780973 noise=0
Ra108 ns108 0 408.27780973 noise=0
Ga107 ns107 0 ns108 0 -0.0179592042053
Ga108 ns108 0 ns107 0 0.0179592042053
Ca109 ns109 0 1e-12
Ca110 ns110 0 1e-12
Ra109 ns109 0 374.088130682 noise=0
Ra110 ns110 0 374.088130682 noise=0
Ga109 ns109 0 ns110 0 -0.0103669856253
Ga110 ns110 0 ns109 0 0.0103669856253
Ca111 ns111 0 1e-12
Ca112 ns112 0 1e-12
Ra111 ns111 0 1931.56177363 noise=0
Ra112 ns112 0 1931.56177363 noise=0
Ga111 ns111 0 ns112 0 -0.0193473747389
Ga112 ns112 0 ns111 0 0.0193473747389
Ca113 ns113 0 1e-12
Ca114 ns114 0 1e-12
Ra113 ns113 0 3071.79101237 noise=0
Ra114 ns114 0 3071.79101237 noise=0
Ga113 ns113 0 ns114 0 -0.00948551518969
Ga114 ns114 0 ns113 0 0.00948551518969
Ca115 ns115 0 1e-12
Ca116 ns116 0 1e-12
Ra115 ns115 0 2318.62067278 noise=0
Ra116 ns116 0 2318.62067278 noise=0
Ga115 ns115 0 ns116 0 -0.0185389316442
Ga116 ns116 0 ns115 0 0.0185389316442
Ca117 ns117 0 1e-12
Ca118 ns118 0 1e-12
Ra117 ns117 0 1261.43612591 noise=0
Ra118 ns118 0 1261.43612591 noise=0
Ga117 ns117 0 ns118 0 -0.0178219092867
Ga118 ns118 0 ns117 0 0.0178219092867
Ca119 ns119 0 1e-12
Ca120 ns120 0 1e-12
Ra119 ns119 0 589.61761212 noise=0
Ra120 ns120 0 589.61761212 noise=0
Ga119 ns119 0 ns120 0 -0.0124034071449
Ga120 ns120 0 ns119 0 0.0124034071449
Ca121 ns121 0 1e-12
Ca122 ns122 0 1e-12
Ra121 ns121 0 2088.12385991 noise=0
Ra122 ns122 0 2088.12385991 noise=0
Ga121 ns121 0 ns122 0 -0.0111604326344
Ga122 ns122 0 ns121 0 0.0111604326344
Ca123 ns123 0 1e-12
Ca124 ns124 0 1e-12
Ra123 ns123 0 3207.80911543 noise=0
Ra124 ns124 0 3207.80911543 noise=0
Ga123 ns123 0 ns124 0 -0.0168742866353
Ga124 ns124 0 ns123 0 0.0168742866353
Ca125 ns125 0 1e-12
Ca126 ns126 0 1e-12
Ra125 ns125 0 4077.32891446 noise=0
Ra126 ns126 0 4077.32891446 noise=0
Ga125 ns125 0 ns126 0 -0.0164639858896
Ga126 ns126 0 ns125 0 0.0164639858896
Ca127 ns127 0 1e-12
Ca128 ns128 0 1e-12
Ra127 ns127 0 4241.11006396 noise=0
Ra128 ns128 0 4241.11006396 noise=0
Ga127 ns127 0 ns128 0 -0.0159909003183
Ga128 ns128 0 ns127 0 0.0159909003183
Ca129 ns129 0 1e-12
Ca130 ns130 0 1e-12
Ra129 ns129 0 3824.28113946 noise=0
Ra130 ns130 0 3824.28113946 noise=0
Ga129 ns129 0 ns130 0 -0.0155195341527
Ga130 ns130 0 ns129 0 0.0155195341527
Ca131 ns131 0 1e-12
Ca132 ns132 0 1e-12
Ra131 ns131 0 2553.4865242 noise=0
Ra132 ns132 0 2553.4865242 noise=0
Ga131 ns131 0 ns132 0 -0.0145648283781
Ga132 ns132 0 ns131 0 0.0145648283781
Ca133 ns133 0 1e-12
Ca134 ns134 0 1e-12
Ra133 ns133 0 3995.3178827 noise=0
Ra134 ns134 0 3995.3178827 noise=0
Ga133 ns133 0 ns134 0 -0.0139253464377
Ga134 ns134 0 ns133 0 0.0139253464377
Ca135 ns135 0 1e-12
Ca136 ns136 0 1e-12
Ra135 ns135 0 4285.29014898 noise=0
Ra136 ns136 0 4285.29014898 noise=0
Ga135 ns135 0 ns136 0 -0.0151661580471
Ga136 ns136 0 ns135 0 0.0151661580471
Ca137 ns137 0 1e-12
Ca138 ns138 0 1e-12
Ra137 ns137 0 16793.3894905 noise=0
Ra138 ns138 0 16793.3894905 noise=0
Ga137 ns137 0 ns138 0 -0.0167238409126
Ga138 ns138 0 ns137 0 0.0167238409126
Ca139 ns139 0 1e-12
Ca140 ns140 0 1e-12
Ra139 ns139 0 3103.81445853 noise=0
Ra140 ns140 0 3103.81445853 noise=0
Ga139 ns139 0 ns140 0 -0.0128945863849
Ga140 ns140 0 ns139 0 0.0128945863849
Ca141 ns141 0 1e-12
Ca142 ns142 0 1e-12
Ra141 ns141 0 14690.330493 noise=0
Ra142 ns142 0 14690.330493 noise=0
Ga141 ns141 0 ns142 0 -0.0120032991301
Ga142 ns142 0 ns141 0 0.0120032991301
Ca143 ns143 0 1e-12
Ca144 ns144 0 1e-12
Ra143 ns143 0 96454.4614957 noise=0
Ra144 ns144 0 96454.4614957 noise=0
Ga143 ns143 0 ns144 0 -0.0119009664267
Ga144 ns144 0 ns143 0 0.0119009664267
Ca145 ns145 0 1e-12
Ca146 ns146 0 1e-12
Ra145 ns145 0 10342.4092713 noise=0
Ra146 ns146 0 10342.4092713 noise=0
Ga145 ns145 0 ns146 0 -0.0122370663137
Ga146 ns146 0 ns145 0 0.0122370663137
Ca147 ns147 0 1e-12
Ca148 ns148 0 1e-12
Ra147 ns147 0 8918.34391013 noise=0
Ra148 ns148 0 8918.34391013 noise=0
Ga147 ns147 0 ns148 0 -0.0126805471413
Ga148 ns148 0 ns147 0 0.0126805471413
Ca149 ns149 0 1e-12
Ca150 ns150 0 1e-12
Ra149 ns149 0 14042.6523429 noise=0
Ra150 ns150 0 14042.6523429 noise=0
Ga149 ns149 0 ns150 0 -0.012900675391
Ga150 ns150 0 ns149 0 0.012900675391
Ca151 ns151 0 1e-12
Ca152 ns152 0 1e-12
Ra151 ns151 0 8.25083067625 noise=0
Ra152 ns152 0 8.25083067625 noise=0
Ga151 ns151 0 ns152 0 -0.0427893075299
Ga152 ns152 0 ns151 0 0.0427893075299
Ca153 ns153 0 1e-12
Ca154 ns154 0 1e-12
Ra153 ns153 0 106.169491387 noise=0
Ra154 ns154 0 106.169491387 noise=0
Ga153 ns153 0 ns154 0 -0.0711386311877
Ga154 ns154 0 ns153 0 0.0711386311877
Ca155 ns155 0 1e-12
Ca156 ns156 0 1e-12
Ra155 ns155 0 714.164477404 noise=0
Ra156 ns156 0 714.164477404 noise=0
Ga155 ns155 0 ns156 0 -0.0649673770601
Ga156 ns156 0 ns155 0 0.0649673770601
Ca157 ns157 0 1e-12
Ca158 ns158 0 1e-12
Ra157 ns157 0 659.637590341 noise=0
Ra158 ns158 0 659.637590341 noise=0
Ga157 ns157 0 ns158 0 -0.0625850853995
Ga158 ns158 0 ns157 0 0.0625850853995
Ca159 ns159 0 1e-12
Ca160 ns160 0 1e-12
Ra159 ns159 0 27454.0019815 noise=0
Ra160 ns160 0 27454.0019815 noise=0
Ga159 ns159 0 ns160 0 -0.0617049463428
Ga160 ns160 0 ns159 0 0.0617049463428
Ca161 ns161 0 1e-12
Ca162 ns162 0 1e-12
Ra161 ns161 0 696.676751258 noise=0
Ra162 ns162 0 696.676751258 noise=0
Ga161 ns161 0 ns162 0 -0.0610299670021
Ga162 ns162 0 ns161 0 0.0610299670021
Ca163 ns163 0 1e-12
Ca164 ns164 0 1e-12
Ra163 ns163 0 944.255939097 noise=0
Ra164 ns164 0 944.255939097 noise=0
Ga163 ns163 0 ns164 0 -0.0596057773168
Ga164 ns164 0 ns163 0 0.0596057773168
Ca165 ns165 0 1e-12
Ca166 ns166 0 1e-12
Ra165 ns165 0 792.645910493 noise=0
Ra166 ns166 0 792.645910493 noise=0
Ga165 ns165 0 ns166 0 -0.0587366995705
Ga166 ns166 0 ns165 0 0.0587366995705
Ca167 ns167 0 1e-12
Ca168 ns168 0 1e-12
Ra167 ns167 0 667.745443679 noise=0
Ra168 ns168 0 667.745443679 noise=0
Ga167 ns167 0 ns168 0 -0.0571177908626
Ga168 ns168 0 ns167 0 0.0571177908626
Ca169 ns169 0 1e-12
Ca170 ns170 0 1e-12
Ra169 ns169 0 683.486879096 noise=0
Ra170 ns170 0 683.486879096 noise=0
Ga169 ns169 0 ns170 0 -0.0551711926529
Ga170 ns170 0 ns169 0 0.0551711926529
Ca171 ns171 0 1e-12
Ca172 ns172 0 1e-12
Ra171 ns171 0 862.471199603 noise=0
Ra172 ns172 0 862.471199603 noise=0
Ga171 ns171 0 ns172 0 -0.0543880261285
Ga172 ns172 0 ns171 0 0.0543880261285
Ca173 ns173 0 1e-12
Ca174 ns174 0 1e-12
Ra173 ns173 0 529.094552392 noise=0
Ra174 ns174 0 529.094552392 noise=0
Ga173 ns173 0 ns174 0 -0.0521921809837
Ga174 ns174 0 ns173 0 0.0521921809837
Ca175 ns175 0 1e-12
Ca176 ns176 0 1e-12
Ra175 ns175 0 1662.50489913 noise=0
Ra176 ns176 0 1662.50489913 noise=0
Ga175 ns175 0 ns176 0 -0.0518326775062
Ga176 ns176 0 ns175 0 0.0518326775062
Ca177 ns177 0 1e-12
Ca178 ns178 0 1e-12
Ra177 ns177 0 823.283626698 noise=0
Ra178 ns178 0 823.283626698 noise=0
Ga177 ns177 0 ns178 0 -0.0503365541484
Ga178 ns178 0 ns177 0 0.0503365541484
Ca179 ns179 0 1e-12
Ca180 ns180 0 1e-12
Ra179 ns179 0 498.747250885 noise=0
Ra180 ns180 0 498.747250885 noise=0
Ga179 ns179 0 ns180 0 -0.0480660213561
Ga180 ns180 0 ns179 0 0.0480660213561
Ca181 ns181 0 1e-12
Ca182 ns182 0 1e-12
Ra181 ns181 0 2400.34571746 noise=0
Ra182 ns182 0 2400.34571746 noise=0
Ga181 ns181 0 ns182 0 -0.0491541733443
Ga182 ns182 0 ns181 0 0.0491541733443
Ca183 ns183 0 1e-12
Ca184 ns184 0 1e-12
Ra183 ns183 0 1789.73820066 noise=0
Ra184 ns184 0 1789.73820066 noise=0
Ga183 ns183 0 ns184 0 -0.0472980535656
Ga184 ns184 0 ns183 0 0.0472980535656
Ca185 ns185 0 1e-12
Ca186 ns186 0 1e-12
Ra185 ns185 0 619.467180392 noise=0
Ra186 ns186 0 619.467180392 noise=0
Ga185 ns185 0 ns186 0 -0.0454172104854
Ga186 ns186 0 ns185 0 0.0454172104854
Ca187 ns187 0 1e-12
Ca188 ns188 0 1e-12
Ra187 ns187 0 1515.47634345 noise=0
Ra188 ns188 0 1515.47634345 noise=0
Ga187 ns187 0 ns188 0 -0.045410084729
Ga188 ns188 0 ns187 0 0.045410084729
Ca189 ns189 0 1e-12
Ca190 ns190 0 1e-12
Ra189 ns189 0 1056.49405077 noise=0
Ra190 ns190 0 1056.49405077 noise=0
Ga189 ns189 0 ns190 0 -0.04352518111
Ga190 ns190 0 ns189 0 0.04352518111
Ca191 ns191 0 1e-12
Ca192 ns192 0 1e-12
Ra191 ns191 0 584.380114574 noise=0
Ra192 ns192 0 584.380114574 noise=0
Ga191 ns191 0 ns192 0 -0.0420110127096
Ga192 ns192 0 ns191 0 0.0420110127096
Ca193 ns193 0 1e-12
Ca194 ns194 0 1e-12
Ra193 ns193 0 1100.37898121 noise=0
Ra194 ns194 0 1100.37898121 noise=0
Ga193 ns193 0 ns194 0 -0.0421057924028
Ga194 ns194 0 ns193 0 0.0421057924028
Ca195 ns195 0 1e-12
Ca196 ns196 0 1e-12
Ra195 ns195 0 2151.05522891 noise=0
Ra196 ns196 0 2151.05522891 noise=0
Ga195 ns195 0 ns196 0 -0.0411613399603
Ga196 ns196 0 ns195 0 0.0411613399603
Ca197 ns197 0 1e-12
Ca198 ns198 0 1e-12
Ra197 ns197 0 925.931226012 noise=0
Ra198 ns198 0 925.931226012 noise=0
Ga197 ns197 0 ns198 0 -0.0394771715126
Ga198 ns198 0 ns197 0 0.0394771715126
Ca199 ns199 0 1e-12
Ca200 ns200 0 1e-12
Ra199 ns199 0 1418.8089157 noise=0
Ra200 ns200 0 1418.8089157 noise=0
Ga199 ns199 0 ns200 0 -0.0387605133287
Ga200 ns200 0 ns199 0 0.0387605133287
Ca201 ns201 0 1e-12
Ca202 ns202 0 1e-12
Ra201 ns201 0 915.223062825 noise=0
Ra202 ns202 0 915.223062825 noise=0
Ga201 ns201 0 ns202 0 -0.0375772253735
Ga202 ns202 0 ns201 0 0.0375772253735
Ca203 ns203 0 1e-12
Ca204 ns204 0 1e-12
Ra203 ns203 0 840.127812543 noise=0
Ra204 ns204 0 840.127812543 noise=0
Ga203 ns203 0 ns204 0 -0.0364938165135
Ga204 ns204 0 ns203 0 0.0364938165135
Ca205 ns205 0 1e-12
Ca206 ns206 0 1e-12
Ra205 ns205 0 652.300622951 noise=0
Ra206 ns206 0 652.300622951 noise=0
Ga205 ns205 0 ns206 0 -0.0345758138052
Ga206 ns206 0 ns205 0 0.0345758138052
Ca207 ns207 0 1e-12
Ca208 ns208 0 1e-12
Ra207 ns207 0 1514.05417225 noise=0
Ra208 ns208 0 1514.05417225 noise=0
Ga207 ns207 0 ns208 0 -0.0349101368215
Ga208 ns208 0 ns207 0 0.0349101368215
Ca209 ns209 0 1e-12
Ca210 ns210 0 1e-12
Ra209 ns209 0 2090.57622699 noise=0
Ra210 ns210 0 2090.57622699 noise=0
Ga209 ns209 0 ns210 0 -0.0330272390634
Ga210 ns210 0 ns209 0 0.0330272390634
Ca211 ns211 0 1e-12
Ca212 ns212 0 1e-12
Ra211 ns211 0 1332.31293014 noise=0
Ra212 ns212 0 1332.31293014 noise=0
Ga211 ns211 0 ns212 0 -0.0327912251637
Ga212 ns212 0 ns211 0 0.0327912251637
Ca213 ns213 0 1e-12
Ca214 ns214 0 1e-12
Ra213 ns213 0 562.450005592 noise=0
Ra214 ns214 0 562.450005592 noise=0
Ga213 ns213 0 ns214 0 -0.031824332533
Ga214 ns214 0 ns213 0 0.031824332533
Ca215 ns215 0 1e-12
Ca216 ns216 0 1e-12
Ra215 ns215 0 2569.70403351 noise=0
Ra216 ns216 0 2569.70403351 noise=0
Ga215 ns215 0 ns216 0 -0.0308554267187
Ga216 ns216 0 ns215 0 0.0308554267187
Ca217 ns217 0 1e-12
Ca218 ns218 0 1e-12
Ra217 ns217 0 1611.59888007 noise=0
Ra218 ns218 0 1611.59888007 noise=0
Ga217 ns217 0 ns218 0 -0.0300762531925
Ga218 ns218 0 ns217 0 0.0300762531925
Ca219 ns219 0 1e-12
Ca220 ns220 0 1e-12
Ra219 ns219 0 9772.30555598 noise=0
Ra220 ns220 0 9772.30555598 noise=0
Ga219 ns219 0 ns220 0 -0.0293102987233
Ga220 ns220 0 ns219 0 0.0293102987233
Ca221 ns221 0 1e-12
Ca222 ns222 0 1e-12
Ra221 ns221 0 719.606922067 noise=0
Ra222 ns222 0 719.606922067 noise=0
Ga221 ns221 0 ns222 0 -0.027902812344
Ga222 ns222 0 ns221 0 0.027902812344
Ca223 ns223 0 1e-12
Ca224 ns224 0 1e-12
Ra223 ns223 0 868.71266533 noise=0
Ra224 ns224 0 868.71266533 noise=0
Ga223 ns223 0 ns224 0 -0.027105710132
Ga224 ns224 0 ns223 0 0.027105710132
Ca225 ns225 0 1e-12
Ca226 ns226 0 1e-12
Ra225 ns225 0 2839.48624926 noise=0
Ra226 ns226 0 2839.48624926 noise=0
Ga225 ns225 0 ns226 0 -0.0273663668076
Ga226 ns226 0 ns225 0 0.0273663668076
Ca227 ns227 0 1e-12
Ca228 ns228 0 1e-12
Ra227 ns227 0 1673.32761037 noise=0
Ra228 ns228 0 1673.32761037 noise=0
Ga227 ns227 0 ns228 0 -0.0258400591067
Ga228 ns228 0 ns227 0 0.0258400591067
Ca229 ns229 0 1e-12
Ca230 ns230 0 1e-12
Ra229 ns229 0 1484.37908566 noise=0
Ra230 ns230 0 1484.37908566 noise=0
Ga229 ns229 0 ns230 0 -0.025495699249
Ga230 ns230 0 ns229 0 0.025495699249
Ca231 ns231 0 1e-12
Ca232 ns232 0 1e-12
Ra231 ns231 0 506.028775389 noise=0
Ra232 ns232 0 506.028775389 noise=0
Ga231 ns231 0 ns232 0 -0.0244848458169
Ga232 ns232 0 ns231 0 0.0244848458169
Ca233 ns233 0 1e-12
Ca234 ns234 0 1e-12
Ra233 ns233 0 2403.73305872 noise=0
Ra234 ns234 0 2403.73305872 noise=0
Ga233 ns233 0 ns234 0 -0.0239731392386
Ga234 ns234 0 ns233 0 0.0239731392386
Ca235 ns235 0 1e-12
Ca236 ns236 0 1e-12
Ra235 ns235 0 336.720349191 noise=0
Ra236 ns236 0 336.720349191 noise=0
Ga235 ns235 0 ns236 0 -0.00305921925757
Ga236 ns236 0 ns235 0 0.00305921925757
Ca237 ns237 0 1e-12
Ra237 ns237 0 625.504211572 noise=0
Ca238 ns238 0 1e-12
Ca239 ns239 0 1e-12
Ra238 ns238 0 430.146675815 noise=0
Ra239 ns239 0 430.146675815 noise=0
Ga238 ns238 0 ns239 0 -0.00415320581989
Ga239 ns239 0 ns238 0 0.00415320581989
Ca240 ns240 0 1e-12
Ra240 ns240 0 17951.6203469 noise=0
Ca241 ns241 0 1e-12
Ca242 ns242 0 1e-12
Ra241 ns241 0 2821.37654478 noise=0
Ra242 ns242 0 2821.37654478 noise=0
Ga241 ns241 0 ns242 0 -0.0232374996199
Ga242 ns242 0 ns241 0 0.0232374996199
Ca243 ns243 0 1e-12
Ca244 ns244 0 1e-12
Ra243 ns243 0 67461.356792 noise=0
Ra244 ns244 0 67461.356792 noise=0
Ga243 ns243 0 ns244 0 -0.0231359324144
Ga244 ns244 0 ns243 0 0.0231359324144
Ca245 ns245 0 1e-12
Ca246 ns246 0 1e-12
Ra245 ns245 0 3882.52713252 noise=0
Ra246 ns246 0 3882.52713252 noise=0
Ga245 ns245 0 ns246 0 -0.0222270795019
Ga246 ns246 0 ns245 0 0.0222270795019
Ca247 ns247 0 1e-12
Ca248 ns248 0 1e-12
Ra247 ns247 0 758.263705618 noise=0
Ra248 ns248 0 758.263705618 noise=0
Ga247 ns247 0 ns248 0 -0.0209094247609
Ga248 ns248 0 ns247 0 0.0209094247609
Ca249 ns249 0 1e-12
Ca250 ns250 0 1e-12
Ra249 ns249 0 8350.80403723 noise=0
Ra250 ns250 0 8350.80403723 noise=0
Ga249 ns249 0 ns250 0 -0.0213852085752
Ga250 ns250 0 ns249 0 0.0213852085752
Ca251 ns251 0 1e-12
Ca252 ns252 0 1e-12
Ra251 ns251 0 616.174027864 noise=0
Ra252 ns252 0 616.174027864 noise=0
Ga251 ns251 0 ns252 0 -0.00740609272703
Ga252 ns252 0 ns251 0 0.00740609272703
Ca253 ns253 0 1e-12
Ca254 ns254 0 1e-12
Ra253 ns253 0 2240.8902644 noise=0
Ra254 ns254 0 2240.8902644 noise=0
Ga253 ns253 0 ns254 0 -0.00746772306658
Ga254 ns254 0 ns253 0 0.00746772306658
Ca255 ns255 0 1e-12
Ca256 ns256 0 1e-12
Ra255 ns255 0 1715.78726301 noise=0
Ra256 ns256 0 1715.78726301 noise=0
Ga255 ns255 0 ns256 0 -0.0202800924869
Ga256 ns256 0 ns255 0 0.0202800924869
Ca257 ns257 0 1e-12
Ca258 ns258 0 1e-12
Ra257 ns257 0 408.27780973 noise=0
Ra258 ns258 0 408.27780973 noise=0
Ga257 ns257 0 ns258 0 -0.0179592042053
Ga258 ns258 0 ns257 0 0.0179592042053
Ca259 ns259 0 1e-12
Ca260 ns260 0 1e-12
Ra259 ns259 0 374.088130682 noise=0
Ra260 ns260 0 374.088130682 noise=0
Ga259 ns259 0 ns260 0 -0.0103669856253
Ga260 ns260 0 ns259 0 0.0103669856253
Ca261 ns261 0 1e-12
Ca262 ns262 0 1e-12
Ra261 ns261 0 1931.56177363 noise=0
Ra262 ns262 0 1931.56177363 noise=0
Ga261 ns261 0 ns262 0 -0.0193473747389
Ga262 ns262 0 ns261 0 0.0193473747389
Ca263 ns263 0 1e-12
Ca264 ns264 0 1e-12
Ra263 ns263 0 3071.79101237 noise=0
Ra264 ns264 0 3071.79101237 noise=0
Ga263 ns263 0 ns264 0 -0.00948551518969
Ga264 ns264 0 ns263 0 0.00948551518969
Ca265 ns265 0 1e-12
Ca266 ns266 0 1e-12
Ra265 ns265 0 2318.62067278 noise=0
Ra266 ns266 0 2318.62067278 noise=0
Ga265 ns265 0 ns266 0 -0.0185389316442
Ga266 ns266 0 ns265 0 0.0185389316442
Ca267 ns267 0 1e-12
Ca268 ns268 0 1e-12
Ra267 ns267 0 1261.43612591 noise=0
Ra268 ns268 0 1261.43612591 noise=0
Ga267 ns267 0 ns268 0 -0.0178219092867
Ga268 ns268 0 ns267 0 0.0178219092867
Ca269 ns269 0 1e-12
Ca270 ns270 0 1e-12
Ra269 ns269 0 589.61761212 noise=0
Ra270 ns270 0 589.61761212 noise=0
Ga269 ns269 0 ns270 0 -0.0124034071449
Ga270 ns270 0 ns269 0 0.0124034071449
Ca271 ns271 0 1e-12
Ca272 ns272 0 1e-12
Ra271 ns271 0 2088.12385991 noise=0
Ra272 ns272 0 2088.12385991 noise=0
Ga271 ns271 0 ns272 0 -0.0111604326344
Ga272 ns272 0 ns271 0 0.0111604326344
Ca273 ns273 0 1e-12
Ca274 ns274 0 1e-12
Ra273 ns273 0 3207.80911543 noise=0
Ra274 ns274 0 3207.80911543 noise=0
Ga273 ns273 0 ns274 0 -0.0168742866353
Ga274 ns274 0 ns273 0 0.0168742866353
Ca275 ns275 0 1e-12
Ca276 ns276 0 1e-12
Ra275 ns275 0 4077.32891446 noise=0
Ra276 ns276 0 4077.32891446 noise=0
Ga275 ns275 0 ns276 0 -0.0164639858896
Ga276 ns276 0 ns275 0 0.0164639858896
Ca277 ns277 0 1e-12
Ca278 ns278 0 1e-12
Ra277 ns277 0 4241.11006396 noise=0
Ra278 ns278 0 4241.11006396 noise=0
Ga277 ns277 0 ns278 0 -0.0159909003183
Ga278 ns278 0 ns277 0 0.0159909003183
Ca279 ns279 0 1e-12
Ca280 ns280 0 1e-12
Ra279 ns279 0 3824.28113946 noise=0
Ra280 ns280 0 3824.28113946 noise=0
Ga279 ns279 0 ns280 0 -0.0155195341527
Ga280 ns280 0 ns279 0 0.0155195341527
Ca281 ns281 0 1e-12
Ca282 ns282 0 1e-12
Ra281 ns281 0 2553.4865242 noise=0
Ra282 ns282 0 2553.4865242 noise=0
Ga281 ns281 0 ns282 0 -0.0145648283781
Ga282 ns282 0 ns281 0 0.0145648283781
Ca283 ns283 0 1e-12
Ca284 ns284 0 1e-12
Ra283 ns283 0 3995.3178827 noise=0
Ra284 ns284 0 3995.3178827 noise=0
Ga283 ns283 0 ns284 0 -0.0139253464377
Ga284 ns284 0 ns283 0 0.0139253464377
Ca285 ns285 0 1e-12
Ca286 ns286 0 1e-12
Ra285 ns285 0 4285.29014898 noise=0
Ra286 ns286 0 4285.29014898 noise=0
Ga285 ns285 0 ns286 0 -0.0151661580471
Ga286 ns286 0 ns285 0 0.0151661580471
Ca287 ns287 0 1e-12
Ca288 ns288 0 1e-12
Ra287 ns287 0 16793.3894905 noise=0
Ra288 ns288 0 16793.3894905 noise=0
Ga287 ns287 0 ns288 0 -0.0167238409126
Ga288 ns288 0 ns287 0 0.0167238409126
Ca289 ns289 0 1e-12
Ca290 ns290 0 1e-12
Ra289 ns289 0 3103.81445853 noise=0
Ra290 ns290 0 3103.81445853 noise=0
Ga289 ns289 0 ns290 0 -0.0128945863849
Ga290 ns290 0 ns289 0 0.0128945863849
Ca291 ns291 0 1e-12
Ca292 ns292 0 1e-12
Ra291 ns291 0 14690.330493 noise=0
Ra292 ns292 0 14690.330493 noise=0
Ga291 ns291 0 ns292 0 -0.0120032991301
Ga292 ns292 0 ns291 0 0.0120032991301
Ca293 ns293 0 1e-12
Ca294 ns294 0 1e-12
Ra293 ns293 0 96454.4614957 noise=0
Ra294 ns294 0 96454.4614957 noise=0
Ga293 ns293 0 ns294 0 -0.0119009664267
Ga294 ns294 0 ns293 0 0.0119009664267
Ca295 ns295 0 1e-12
Ca296 ns296 0 1e-12
Ra295 ns295 0 10342.4092713 noise=0
Ra296 ns296 0 10342.4092713 noise=0
Ga295 ns295 0 ns296 0 -0.0122370663137
Ga296 ns296 0 ns295 0 0.0122370663137
Ca297 ns297 0 1e-12
Ca298 ns298 0 1e-12
Ra297 ns297 0 8918.34391013 noise=0
Ra298 ns298 0 8918.34391013 noise=0
Ga297 ns297 0 ns298 0 -0.0126805471413
Ga298 ns298 0 ns297 0 0.0126805471413
Ca299 ns299 0 1e-12
Ca300 ns300 0 1e-12
Ra299 ns299 0 14042.6523429 noise=0
Ra300 ns300 0 14042.6523429 noise=0
Ga299 ns299 0 ns300 0 -0.012900675391
Ga300 ns300 0 ns299 0 0.012900675391
Ca301 ns301 0 1e-12
Ca302 ns302 0 1e-12
Ra301 ns301 0 8.25083067625 noise=0
Ra302 ns302 0 8.25083067625 noise=0
Ga301 ns301 0 ns302 0 -0.0427893075299
Ga302 ns302 0 ns301 0 0.0427893075299
Ca303 ns303 0 1e-12
Ca304 ns304 0 1e-12
Ra303 ns303 0 106.169491387 noise=0
Ra304 ns304 0 106.169491387 noise=0
Ga303 ns303 0 ns304 0 -0.0711386311877
Ga304 ns304 0 ns303 0 0.0711386311877
Ca305 ns305 0 1e-12
Ca306 ns306 0 1e-12
Ra305 ns305 0 714.164477404 noise=0
Ra306 ns306 0 714.164477404 noise=0
Ga305 ns305 0 ns306 0 -0.0649673770601
Ga306 ns306 0 ns305 0 0.0649673770601
Ca307 ns307 0 1e-12
Ca308 ns308 0 1e-12
Ra307 ns307 0 659.637590341 noise=0
Ra308 ns308 0 659.637590341 noise=0
Ga307 ns307 0 ns308 0 -0.0625850853995
Ga308 ns308 0 ns307 0 0.0625850853995
Ca309 ns309 0 1e-12
Ca310 ns310 0 1e-12
Ra309 ns309 0 27454.0019815 noise=0
Ra310 ns310 0 27454.0019815 noise=0
Ga309 ns309 0 ns310 0 -0.0617049463428
Ga310 ns310 0 ns309 0 0.0617049463428
Ca311 ns311 0 1e-12
Ca312 ns312 0 1e-12
Ra311 ns311 0 696.676751258 noise=0
Ra312 ns312 0 696.676751258 noise=0
Ga311 ns311 0 ns312 0 -0.0610299670021
Ga312 ns312 0 ns311 0 0.0610299670021
Ca313 ns313 0 1e-12
Ca314 ns314 0 1e-12
Ra313 ns313 0 944.255939097 noise=0
Ra314 ns314 0 944.255939097 noise=0
Ga313 ns313 0 ns314 0 -0.0596057773168
Ga314 ns314 0 ns313 0 0.0596057773168
Ca315 ns315 0 1e-12
Ca316 ns316 0 1e-12
Ra315 ns315 0 792.645910493 noise=0
Ra316 ns316 0 792.645910493 noise=0
Ga315 ns315 0 ns316 0 -0.0587366995705
Ga316 ns316 0 ns315 0 0.0587366995705
Ca317 ns317 0 1e-12
Ca318 ns318 0 1e-12
Ra317 ns317 0 667.745443679 noise=0
Ra318 ns318 0 667.745443679 noise=0
Ga317 ns317 0 ns318 0 -0.0571177908626
Ga318 ns318 0 ns317 0 0.0571177908626
Ca319 ns319 0 1e-12
Ca320 ns320 0 1e-12
Ra319 ns319 0 683.486879096 noise=0
Ra320 ns320 0 683.486879096 noise=0
Ga319 ns319 0 ns320 0 -0.0551711926529
Ga320 ns320 0 ns319 0 0.0551711926529
Ca321 ns321 0 1e-12
Ca322 ns322 0 1e-12
Ra321 ns321 0 862.471199603 noise=0
Ra322 ns322 0 862.471199603 noise=0
Ga321 ns321 0 ns322 0 -0.0543880261285
Ga322 ns322 0 ns321 0 0.0543880261285
Ca323 ns323 0 1e-12
Ca324 ns324 0 1e-12
Ra323 ns323 0 529.094552392 noise=0
Ra324 ns324 0 529.094552392 noise=0
Ga323 ns323 0 ns324 0 -0.0521921809837
Ga324 ns324 0 ns323 0 0.0521921809837
Ca325 ns325 0 1e-12
Ca326 ns326 0 1e-12
Ra325 ns325 0 1662.50489913 noise=0
Ra326 ns326 0 1662.50489913 noise=0
Ga325 ns325 0 ns326 0 -0.0518326775062
Ga326 ns326 0 ns325 0 0.0518326775062
Ca327 ns327 0 1e-12
Ca328 ns328 0 1e-12
Ra327 ns327 0 823.283626698 noise=0
Ra328 ns328 0 823.283626698 noise=0
Ga327 ns327 0 ns328 0 -0.0503365541484
Ga328 ns328 0 ns327 0 0.0503365541484
Ca329 ns329 0 1e-12
Ca330 ns330 0 1e-12
Ra329 ns329 0 498.747250885 noise=0
Ra330 ns330 0 498.747250885 noise=0
Ga329 ns329 0 ns330 0 -0.0480660213561
Ga330 ns330 0 ns329 0 0.0480660213561
Ca331 ns331 0 1e-12
Ca332 ns332 0 1e-12
Ra331 ns331 0 2400.34571746 noise=0
Ra332 ns332 0 2400.34571746 noise=0
Ga331 ns331 0 ns332 0 -0.0491541733443
Ga332 ns332 0 ns331 0 0.0491541733443
Ca333 ns333 0 1e-12
Ca334 ns334 0 1e-12
Ra333 ns333 0 1789.73820066 noise=0
Ra334 ns334 0 1789.73820066 noise=0
Ga333 ns333 0 ns334 0 -0.0472980535656
Ga334 ns334 0 ns333 0 0.0472980535656
Ca335 ns335 0 1e-12
Ca336 ns336 0 1e-12
Ra335 ns335 0 619.467180392 noise=0
Ra336 ns336 0 619.467180392 noise=0
Ga335 ns335 0 ns336 0 -0.0454172104854
Ga336 ns336 0 ns335 0 0.0454172104854
Ca337 ns337 0 1e-12
Ca338 ns338 0 1e-12
Ra337 ns337 0 1515.47634345 noise=0
Ra338 ns338 0 1515.47634345 noise=0
Ga337 ns337 0 ns338 0 -0.045410084729
Ga338 ns338 0 ns337 0 0.045410084729
Ca339 ns339 0 1e-12
Ca340 ns340 0 1e-12
Ra339 ns339 0 1056.49405077 noise=0
Ra340 ns340 0 1056.49405077 noise=0
Ga339 ns339 0 ns340 0 -0.04352518111
Ga340 ns340 0 ns339 0 0.04352518111
Ca341 ns341 0 1e-12
Ca342 ns342 0 1e-12
Ra341 ns341 0 584.380114574 noise=0
Ra342 ns342 0 584.380114574 noise=0
Ga341 ns341 0 ns342 0 -0.0420110127096
Ga342 ns342 0 ns341 0 0.0420110127096
Ca343 ns343 0 1e-12
Ca344 ns344 0 1e-12
Ra343 ns343 0 1100.37898121 noise=0
Ra344 ns344 0 1100.37898121 noise=0
Ga343 ns343 0 ns344 0 -0.0421057924028
Ga344 ns344 0 ns343 0 0.0421057924028
Ca345 ns345 0 1e-12
Ca346 ns346 0 1e-12
Ra345 ns345 0 2151.05522891 noise=0
Ra346 ns346 0 2151.05522891 noise=0
Ga345 ns345 0 ns346 0 -0.0411613399603
Ga346 ns346 0 ns345 0 0.0411613399603
Ca347 ns347 0 1e-12
Ca348 ns348 0 1e-12
Ra347 ns347 0 925.931226012 noise=0
Ra348 ns348 0 925.931226012 noise=0
Ga347 ns347 0 ns348 0 -0.0394771715126
Ga348 ns348 0 ns347 0 0.0394771715126
Ca349 ns349 0 1e-12
Ca350 ns350 0 1e-12
Ra349 ns349 0 1418.8089157 noise=0
Ra350 ns350 0 1418.8089157 noise=0
Ga349 ns349 0 ns350 0 -0.0387605133287
Ga350 ns350 0 ns349 0 0.0387605133287
Ca351 ns351 0 1e-12
Ca352 ns352 0 1e-12
Ra351 ns351 0 915.223062825 noise=0
Ra352 ns352 0 915.223062825 noise=0
Ga351 ns351 0 ns352 0 -0.0375772253735
Ga352 ns352 0 ns351 0 0.0375772253735
Ca353 ns353 0 1e-12
Ca354 ns354 0 1e-12
Ra353 ns353 0 840.127812543 noise=0
Ra354 ns354 0 840.127812543 noise=0
Ga353 ns353 0 ns354 0 -0.0364938165135
Ga354 ns354 0 ns353 0 0.0364938165135
Ca355 ns355 0 1e-12
Ca356 ns356 0 1e-12
Ra355 ns355 0 652.300622951 noise=0
Ra356 ns356 0 652.300622951 noise=0
Ga355 ns355 0 ns356 0 -0.0345758138052
Ga356 ns356 0 ns355 0 0.0345758138052
Ca357 ns357 0 1e-12
Ca358 ns358 0 1e-12
Ra357 ns357 0 1514.05417225 noise=0
Ra358 ns358 0 1514.05417225 noise=0
Ga357 ns357 0 ns358 0 -0.0349101368215
Ga358 ns358 0 ns357 0 0.0349101368215
Ca359 ns359 0 1e-12
Ca360 ns360 0 1e-12
Ra359 ns359 0 2090.57622699 noise=0
Ra360 ns360 0 2090.57622699 noise=0
Ga359 ns359 0 ns360 0 -0.0330272390634
Ga360 ns360 0 ns359 0 0.0330272390634
Ca361 ns361 0 1e-12
Ca362 ns362 0 1e-12
Ra361 ns361 0 1332.31293014 noise=0
Ra362 ns362 0 1332.31293014 noise=0
Ga361 ns361 0 ns362 0 -0.0327912251637
Ga362 ns362 0 ns361 0 0.0327912251637
Ca363 ns363 0 1e-12
Ca364 ns364 0 1e-12
Ra363 ns363 0 562.450005592 noise=0
Ra364 ns364 0 562.450005592 noise=0
Ga363 ns363 0 ns364 0 -0.031824332533
Ga364 ns364 0 ns363 0 0.031824332533
Ca365 ns365 0 1e-12
Ca366 ns366 0 1e-12
Ra365 ns365 0 2569.70403351 noise=0
Ra366 ns366 0 2569.70403351 noise=0
Ga365 ns365 0 ns366 0 -0.0308554267187
Ga366 ns366 0 ns365 0 0.0308554267187
Ca367 ns367 0 1e-12
Ca368 ns368 0 1e-12
Ra367 ns367 0 1611.59888007 noise=0
Ra368 ns368 0 1611.59888007 noise=0
Ga367 ns367 0 ns368 0 -0.0300762531925
Ga368 ns368 0 ns367 0 0.0300762531925
Ca369 ns369 0 1e-12
Ca370 ns370 0 1e-12
Ra369 ns369 0 9772.30555598 noise=0
Ra370 ns370 0 9772.30555598 noise=0
Ga369 ns369 0 ns370 0 -0.0293102987233
Ga370 ns370 0 ns369 0 0.0293102987233
Ca371 ns371 0 1e-12
Ca372 ns372 0 1e-12
Ra371 ns371 0 719.606922067 noise=0
Ra372 ns372 0 719.606922067 noise=0
Ga371 ns371 0 ns372 0 -0.027902812344
Ga372 ns372 0 ns371 0 0.027902812344
Ca373 ns373 0 1e-12
Ca374 ns374 0 1e-12
Ra373 ns373 0 868.71266533 noise=0
Ra374 ns374 0 868.71266533 noise=0
Ga373 ns373 0 ns374 0 -0.027105710132
Ga374 ns374 0 ns373 0 0.027105710132
Ca375 ns375 0 1e-12
Ca376 ns376 0 1e-12
Ra375 ns375 0 2839.48624926 noise=0
Ra376 ns376 0 2839.48624926 noise=0
Ga375 ns375 0 ns376 0 -0.0273663668076
Ga376 ns376 0 ns375 0 0.0273663668076
Ca377 ns377 0 1e-12
Ca378 ns378 0 1e-12
Ra377 ns377 0 1673.32761037 noise=0
Ra378 ns378 0 1673.32761037 noise=0
Ga377 ns377 0 ns378 0 -0.0258400591067
Ga378 ns378 0 ns377 0 0.0258400591067
Ca379 ns379 0 1e-12
Ca380 ns380 0 1e-12
Ra379 ns379 0 1484.37908566 noise=0
Ra380 ns380 0 1484.37908566 noise=0
Ga379 ns379 0 ns380 0 -0.025495699249
Ga380 ns380 0 ns379 0 0.025495699249
Ca381 ns381 0 1e-12
Ca382 ns382 0 1e-12
Ra381 ns381 0 506.028775389 noise=0
Ra382 ns382 0 506.028775389 noise=0
Ga381 ns381 0 ns382 0 -0.0244848458169
Ga382 ns382 0 ns381 0 0.0244848458169
Ca383 ns383 0 1e-12
Ca384 ns384 0 1e-12
Ra383 ns383 0 2403.73305872 noise=0
Ra384 ns384 0 2403.73305872 noise=0
Ga383 ns383 0 ns384 0 -0.0239731392386
Ga384 ns384 0 ns383 0 0.0239731392386
Ca385 ns385 0 1e-12
Ca386 ns386 0 1e-12
Ra385 ns385 0 336.720349191 noise=0
Ra386 ns386 0 336.720349191 noise=0
Ga385 ns385 0 ns386 0 -0.00305921925757
Ga386 ns386 0 ns385 0 0.00305921925757
Ca387 ns387 0 1e-12
Ra387 ns387 0 625.504211572 noise=0
Ca388 ns388 0 1e-12
Ca389 ns389 0 1e-12
Ra388 ns388 0 430.146675815 noise=0
Ra389 ns389 0 430.146675815 noise=0
Ga388 ns388 0 ns389 0 -0.00415320581989
Ga389 ns389 0 ns388 0 0.00415320581989
Ca390 ns390 0 1e-12
Ra390 ns390 0 17951.6203469 noise=0
Ca391 ns391 0 1e-12
Ca392 ns392 0 1e-12
Ra391 ns391 0 2821.37654478 noise=0
Ra392 ns392 0 2821.37654478 noise=0
Ga391 ns391 0 ns392 0 -0.0232374996199
Ga392 ns392 0 ns391 0 0.0232374996199
Ca393 ns393 0 1e-12
Ca394 ns394 0 1e-12
Ra393 ns393 0 67461.356792 noise=0
Ra394 ns394 0 67461.356792 noise=0
Ga393 ns393 0 ns394 0 -0.0231359324144
Ga394 ns394 0 ns393 0 0.0231359324144
Ca395 ns395 0 1e-12
Ca396 ns396 0 1e-12
Ra395 ns395 0 3882.52713252 noise=0
Ra396 ns396 0 3882.52713252 noise=0
Ga395 ns395 0 ns396 0 -0.0222270795019
Ga396 ns396 0 ns395 0 0.0222270795019
Ca397 ns397 0 1e-12
Ca398 ns398 0 1e-12
Ra397 ns397 0 758.263705618 noise=0
Ra398 ns398 0 758.263705618 noise=0
Ga397 ns397 0 ns398 0 -0.0209094247609
Ga398 ns398 0 ns397 0 0.0209094247609
Ca399 ns399 0 1e-12
Ca400 ns400 0 1e-12
Ra399 ns399 0 8350.80403723 noise=0
Ra400 ns400 0 8350.80403723 noise=0
Ga399 ns399 0 ns400 0 -0.0213852085752
Ga400 ns400 0 ns399 0 0.0213852085752
Ca401 ns401 0 1e-12
Ca402 ns402 0 1e-12
Ra401 ns401 0 616.174027864 noise=0
Ra402 ns402 0 616.174027864 noise=0
Ga401 ns401 0 ns402 0 -0.00740609272703
Ga402 ns402 0 ns401 0 0.00740609272703
Ca403 ns403 0 1e-12
Ca404 ns404 0 1e-12
Ra403 ns403 0 2240.8902644 noise=0
Ra404 ns404 0 2240.8902644 noise=0
Ga403 ns403 0 ns404 0 -0.00746772306658
Ga404 ns404 0 ns403 0 0.00746772306658
Ca405 ns405 0 1e-12
Ca406 ns406 0 1e-12
Ra405 ns405 0 1715.78726301 noise=0
Ra406 ns406 0 1715.78726301 noise=0
Ga405 ns405 0 ns406 0 -0.0202800924869
Ga406 ns406 0 ns405 0 0.0202800924869
Ca407 ns407 0 1e-12
Ca408 ns408 0 1e-12
Ra407 ns407 0 408.27780973 noise=0
Ra408 ns408 0 408.27780973 noise=0
Ga407 ns407 0 ns408 0 -0.0179592042053
Ga408 ns408 0 ns407 0 0.0179592042053
Ca409 ns409 0 1e-12
Ca410 ns410 0 1e-12
Ra409 ns409 0 374.088130682 noise=0
Ra410 ns410 0 374.088130682 noise=0
Ga409 ns409 0 ns410 0 -0.0103669856253
Ga410 ns410 0 ns409 0 0.0103669856253
Ca411 ns411 0 1e-12
Ca412 ns412 0 1e-12
Ra411 ns411 0 1931.56177363 noise=0
Ra412 ns412 0 1931.56177363 noise=0
Ga411 ns411 0 ns412 0 -0.0193473747389
Ga412 ns412 0 ns411 0 0.0193473747389
Ca413 ns413 0 1e-12
Ca414 ns414 0 1e-12
Ra413 ns413 0 3071.79101237 noise=0
Ra414 ns414 0 3071.79101237 noise=0
Ga413 ns413 0 ns414 0 -0.00948551518969
Ga414 ns414 0 ns413 0 0.00948551518969
Ca415 ns415 0 1e-12
Ca416 ns416 0 1e-12
Ra415 ns415 0 2318.62067278 noise=0
Ra416 ns416 0 2318.62067278 noise=0
Ga415 ns415 0 ns416 0 -0.0185389316442
Ga416 ns416 0 ns415 0 0.0185389316442
Ca417 ns417 0 1e-12
Ca418 ns418 0 1e-12
Ra417 ns417 0 1261.43612591 noise=0
Ra418 ns418 0 1261.43612591 noise=0
Ga417 ns417 0 ns418 0 -0.0178219092867
Ga418 ns418 0 ns417 0 0.0178219092867
Ca419 ns419 0 1e-12
Ca420 ns420 0 1e-12
Ra419 ns419 0 589.61761212 noise=0
Ra420 ns420 0 589.61761212 noise=0
Ga419 ns419 0 ns420 0 -0.0124034071449
Ga420 ns420 0 ns419 0 0.0124034071449
Ca421 ns421 0 1e-12
Ca422 ns422 0 1e-12
Ra421 ns421 0 2088.12385991 noise=0
Ra422 ns422 0 2088.12385991 noise=0
Ga421 ns421 0 ns422 0 -0.0111604326344
Ga422 ns422 0 ns421 0 0.0111604326344
Ca423 ns423 0 1e-12
Ca424 ns424 0 1e-12
Ra423 ns423 0 3207.80911543 noise=0
Ra424 ns424 0 3207.80911543 noise=0
Ga423 ns423 0 ns424 0 -0.0168742866353
Ga424 ns424 0 ns423 0 0.0168742866353
Ca425 ns425 0 1e-12
Ca426 ns426 0 1e-12
Ra425 ns425 0 4077.32891446 noise=0
Ra426 ns426 0 4077.32891446 noise=0
Ga425 ns425 0 ns426 0 -0.0164639858896
Ga426 ns426 0 ns425 0 0.0164639858896
Ca427 ns427 0 1e-12
Ca428 ns428 0 1e-12
Ra427 ns427 0 4241.11006396 noise=0
Ra428 ns428 0 4241.11006396 noise=0
Ga427 ns427 0 ns428 0 -0.0159909003183
Ga428 ns428 0 ns427 0 0.0159909003183
Ca429 ns429 0 1e-12
Ca430 ns430 0 1e-12
Ra429 ns429 0 3824.28113946 noise=0
Ra430 ns430 0 3824.28113946 noise=0
Ga429 ns429 0 ns430 0 -0.0155195341527
Ga430 ns430 0 ns429 0 0.0155195341527
Ca431 ns431 0 1e-12
Ca432 ns432 0 1e-12
Ra431 ns431 0 2553.4865242 noise=0
Ra432 ns432 0 2553.4865242 noise=0
Ga431 ns431 0 ns432 0 -0.0145648283781
Ga432 ns432 0 ns431 0 0.0145648283781
Ca433 ns433 0 1e-12
Ca434 ns434 0 1e-12
Ra433 ns433 0 3995.3178827 noise=0
Ra434 ns434 0 3995.3178827 noise=0
Ga433 ns433 0 ns434 0 -0.0139253464377
Ga434 ns434 0 ns433 0 0.0139253464377
Ca435 ns435 0 1e-12
Ca436 ns436 0 1e-12
Ra435 ns435 0 4285.29014898 noise=0
Ra436 ns436 0 4285.29014898 noise=0
Ga435 ns435 0 ns436 0 -0.0151661580471
Ga436 ns436 0 ns435 0 0.0151661580471
Ca437 ns437 0 1e-12
Ca438 ns438 0 1e-12
Ra437 ns437 0 16793.3894905 noise=0
Ra438 ns438 0 16793.3894905 noise=0
Ga437 ns437 0 ns438 0 -0.0167238409126
Ga438 ns438 0 ns437 0 0.0167238409126
Ca439 ns439 0 1e-12
Ca440 ns440 0 1e-12
Ra439 ns439 0 3103.81445853 noise=0
Ra440 ns440 0 3103.81445853 noise=0
Ga439 ns439 0 ns440 0 -0.0128945863849
Ga440 ns440 0 ns439 0 0.0128945863849
Ca441 ns441 0 1e-12
Ca442 ns442 0 1e-12
Ra441 ns441 0 14690.330493 noise=0
Ra442 ns442 0 14690.330493 noise=0
Ga441 ns441 0 ns442 0 -0.0120032991301
Ga442 ns442 0 ns441 0 0.0120032991301
Ca443 ns443 0 1e-12
Ca444 ns444 0 1e-12
Ra443 ns443 0 96454.4614957 noise=0
Ra444 ns444 0 96454.4614957 noise=0
Ga443 ns443 0 ns444 0 -0.0119009664267
Ga444 ns444 0 ns443 0 0.0119009664267
Ca445 ns445 0 1e-12
Ca446 ns446 0 1e-12
Ra445 ns445 0 10342.4092713 noise=0
Ra446 ns446 0 10342.4092713 noise=0
Ga445 ns445 0 ns446 0 -0.0122370663137
Ga446 ns446 0 ns445 0 0.0122370663137
Ca447 ns447 0 1e-12
Ca448 ns448 0 1e-12
Ra447 ns447 0 8918.34391013 noise=0
Ra448 ns448 0 8918.34391013 noise=0
Ga447 ns447 0 ns448 0 -0.0126805471413
Ga448 ns448 0 ns447 0 0.0126805471413
Ca449 ns449 0 1e-12
Ca450 ns450 0 1e-12
Ra449 ns449 0 14042.6523429 noise=0
Ra450 ns450 0 14042.6523429 noise=0
Ga449 ns449 0 ns450 0 -0.012900675391
Ga450 ns450 0 ns449 0 0.012900675391
Ca451 ns451 0 1e-12
Ca452 ns452 0 1e-12
Ra451 ns451 0 8.25083067625 noise=0
Ra452 ns452 0 8.25083067625 noise=0
Ga451 ns451 0 ns452 0 -0.0427893075299
Ga452 ns452 0 ns451 0 0.0427893075299
Ca453 ns453 0 1e-12
Ca454 ns454 0 1e-12
Ra453 ns453 0 106.169491387 noise=0
Ra454 ns454 0 106.169491387 noise=0
Ga453 ns453 0 ns454 0 -0.0711386311877
Ga454 ns454 0 ns453 0 0.0711386311877
Ca455 ns455 0 1e-12
Ca456 ns456 0 1e-12
Ra455 ns455 0 714.164477404 noise=0
Ra456 ns456 0 714.164477404 noise=0
Ga455 ns455 0 ns456 0 -0.0649673770601
Ga456 ns456 0 ns455 0 0.0649673770601
Ca457 ns457 0 1e-12
Ca458 ns458 0 1e-12
Ra457 ns457 0 659.637590341 noise=0
Ra458 ns458 0 659.637590341 noise=0
Ga457 ns457 0 ns458 0 -0.0625850853995
Ga458 ns458 0 ns457 0 0.0625850853995
Ca459 ns459 0 1e-12
Ca460 ns460 0 1e-12
Ra459 ns459 0 27454.0019815 noise=0
Ra460 ns460 0 27454.0019815 noise=0
Ga459 ns459 0 ns460 0 -0.0617049463428
Ga460 ns460 0 ns459 0 0.0617049463428
Ca461 ns461 0 1e-12
Ca462 ns462 0 1e-12
Ra461 ns461 0 696.676751258 noise=0
Ra462 ns462 0 696.676751258 noise=0
Ga461 ns461 0 ns462 0 -0.0610299670021
Ga462 ns462 0 ns461 0 0.0610299670021
Ca463 ns463 0 1e-12
Ca464 ns464 0 1e-12
Ra463 ns463 0 944.255939097 noise=0
Ra464 ns464 0 944.255939097 noise=0
Ga463 ns463 0 ns464 0 -0.0596057773168
Ga464 ns464 0 ns463 0 0.0596057773168
Ca465 ns465 0 1e-12
Ca466 ns466 0 1e-12
Ra465 ns465 0 792.645910493 noise=0
Ra466 ns466 0 792.645910493 noise=0
Ga465 ns465 0 ns466 0 -0.0587366995705
Ga466 ns466 0 ns465 0 0.0587366995705
Ca467 ns467 0 1e-12
Ca468 ns468 0 1e-12
Ra467 ns467 0 667.745443679 noise=0
Ra468 ns468 0 667.745443679 noise=0
Ga467 ns467 0 ns468 0 -0.0571177908626
Ga468 ns468 0 ns467 0 0.0571177908626
Ca469 ns469 0 1e-12
Ca470 ns470 0 1e-12
Ra469 ns469 0 683.486879096 noise=0
Ra470 ns470 0 683.486879096 noise=0
Ga469 ns469 0 ns470 0 -0.0551711926529
Ga470 ns470 0 ns469 0 0.0551711926529
Ca471 ns471 0 1e-12
Ca472 ns472 0 1e-12
Ra471 ns471 0 862.471199603 noise=0
Ra472 ns472 0 862.471199603 noise=0
Ga471 ns471 0 ns472 0 -0.0543880261285
Ga472 ns472 0 ns471 0 0.0543880261285
Ca473 ns473 0 1e-12
Ca474 ns474 0 1e-12
Ra473 ns473 0 529.094552392 noise=0
Ra474 ns474 0 529.094552392 noise=0
Ga473 ns473 0 ns474 0 -0.0521921809837
Ga474 ns474 0 ns473 0 0.0521921809837
Ca475 ns475 0 1e-12
Ca476 ns476 0 1e-12
Ra475 ns475 0 1662.50489913 noise=0
Ra476 ns476 0 1662.50489913 noise=0
Ga475 ns475 0 ns476 0 -0.0518326775062
Ga476 ns476 0 ns475 0 0.0518326775062
Ca477 ns477 0 1e-12
Ca478 ns478 0 1e-12
Ra477 ns477 0 823.283626698 noise=0
Ra478 ns478 0 823.283626698 noise=0
Ga477 ns477 0 ns478 0 -0.0503365541484
Ga478 ns478 0 ns477 0 0.0503365541484
Ca479 ns479 0 1e-12
Ca480 ns480 0 1e-12
Ra479 ns479 0 498.747250885 noise=0
Ra480 ns480 0 498.747250885 noise=0
Ga479 ns479 0 ns480 0 -0.0480660213561
Ga480 ns480 0 ns479 0 0.0480660213561
Ca481 ns481 0 1e-12
Ca482 ns482 0 1e-12
Ra481 ns481 0 2400.34571746 noise=0
Ra482 ns482 0 2400.34571746 noise=0
Ga481 ns481 0 ns482 0 -0.0491541733443
Ga482 ns482 0 ns481 0 0.0491541733443
Ca483 ns483 0 1e-12
Ca484 ns484 0 1e-12
Ra483 ns483 0 1789.73820066 noise=0
Ra484 ns484 0 1789.73820066 noise=0
Ga483 ns483 0 ns484 0 -0.0472980535656
Ga484 ns484 0 ns483 0 0.0472980535656
Ca485 ns485 0 1e-12
Ca486 ns486 0 1e-12
Ra485 ns485 0 619.467180392 noise=0
Ra486 ns486 0 619.467180392 noise=0
Ga485 ns485 0 ns486 0 -0.0454172104854
Ga486 ns486 0 ns485 0 0.0454172104854
Ca487 ns487 0 1e-12
Ca488 ns488 0 1e-12
Ra487 ns487 0 1515.47634345 noise=0
Ra488 ns488 0 1515.47634345 noise=0
Ga487 ns487 0 ns488 0 -0.045410084729
Ga488 ns488 0 ns487 0 0.045410084729
Ca489 ns489 0 1e-12
Ca490 ns490 0 1e-12
Ra489 ns489 0 1056.49405077 noise=0
Ra490 ns490 0 1056.49405077 noise=0
Ga489 ns489 0 ns490 0 -0.04352518111
Ga490 ns490 0 ns489 0 0.04352518111
Ca491 ns491 0 1e-12
Ca492 ns492 0 1e-12
Ra491 ns491 0 584.380114574 noise=0
Ra492 ns492 0 584.380114574 noise=0
Ga491 ns491 0 ns492 0 -0.0420110127096
Ga492 ns492 0 ns491 0 0.0420110127096
Ca493 ns493 0 1e-12
Ca494 ns494 0 1e-12
Ra493 ns493 0 1100.37898121 noise=0
Ra494 ns494 0 1100.37898121 noise=0
Ga493 ns493 0 ns494 0 -0.0421057924028
Ga494 ns494 0 ns493 0 0.0421057924028
Ca495 ns495 0 1e-12
Ca496 ns496 0 1e-12
Ra495 ns495 0 2151.05522891 noise=0
Ra496 ns496 0 2151.05522891 noise=0
Ga495 ns495 0 ns496 0 -0.0411613399603
Ga496 ns496 0 ns495 0 0.0411613399603
Ca497 ns497 0 1e-12
Ca498 ns498 0 1e-12
Ra497 ns497 0 925.931226012 noise=0
Ra498 ns498 0 925.931226012 noise=0
Ga497 ns497 0 ns498 0 -0.0394771715126
Ga498 ns498 0 ns497 0 0.0394771715126
Ca499 ns499 0 1e-12
Ca500 ns500 0 1e-12
Ra499 ns499 0 1418.8089157 noise=0
Ra500 ns500 0 1418.8089157 noise=0
Ga499 ns499 0 ns500 0 -0.0387605133287
Ga500 ns500 0 ns499 0 0.0387605133287
Ca501 ns501 0 1e-12
Ca502 ns502 0 1e-12
Ra501 ns501 0 915.223062825 noise=0
Ra502 ns502 0 915.223062825 noise=0
Ga501 ns501 0 ns502 0 -0.0375772253735
Ga502 ns502 0 ns501 0 0.0375772253735
Ca503 ns503 0 1e-12
Ca504 ns504 0 1e-12
Ra503 ns503 0 840.127812543 noise=0
Ra504 ns504 0 840.127812543 noise=0
Ga503 ns503 0 ns504 0 -0.0364938165135
Ga504 ns504 0 ns503 0 0.0364938165135
Ca505 ns505 0 1e-12
Ca506 ns506 0 1e-12
Ra505 ns505 0 652.300622951 noise=0
Ra506 ns506 0 652.300622951 noise=0
Ga505 ns505 0 ns506 0 -0.0345758138052
Ga506 ns506 0 ns505 0 0.0345758138052
Ca507 ns507 0 1e-12
Ca508 ns508 0 1e-12
Ra507 ns507 0 1514.05417225 noise=0
Ra508 ns508 0 1514.05417225 noise=0
Ga507 ns507 0 ns508 0 -0.0349101368215
Ga508 ns508 0 ns507 0 0.0349101368215
Ca509 ns509 0 1e-12
Ca510 ns510 0 1e-12
Ra509 ns509 0 2090.57622699 noise=0
Ra510 ns510 0 2090.57622699 noise=0
Ga509 ns509 0 ns510 0 -0.0330272390634
Ga510 ns510 0 ns509 0 0.0330272390634
Ca511 ns511 0 1e-12
Ca512 ns512 0 1e-12
Ra511 ns511 0 1332.31293014 noise=0
Ra512 ns512 0 1332.31293014 noise=0
Ga511 ns511 0 ns512 0 -0.0327912251637
Ga512 ns512 0 ns511 0 0.0327912251637
Ca513 ns513 0 1e-12
Ca514 ns514 0 1e-12
Ra513 ns513 0 562.450005592 noise=0
Ra514 ns514 0 562.450005592 noise=0
Ga513 ns513 0 ns514 0 -0.031824332533
Ga514 ns514 0 ns513 0 0.031824332533
Ca515 ns515 0 1e-12
Ca516 ns516 0 1e-12
Ra515 ns515 0 2569.70403351 noise=0
Ra516 ns516 0 2569.70403351 noise=0
Ga515 ns515 0 ns516 0 -0.0308554267187
Ga516 ns516 0 ns515 0 0.0308554267187
Ca517 ns517 0 1e-12
Ca518 ns518 0 1e-12
Ra517 ns517 0 1611.59888007 noise=0
Ra518 ns518 0 1611.59888007 noise=0
Ga517 ns517 0 ns518 0 -0.0300762531925
Ga518 ns518 0 ns517 0 0.0300762531925
Ca519 ns519 0 1e-12
Ca520 ns520 0 1e-12
Ra519 ns519 0 9772.30555598 noise=0
Ra520 ns520 0 9772.30555598 noise=0
Ga519 ns519 0 ns520 0 -0.0293102987233
Ga520 ns520 0 ns519 0 0.0293102987233
Ca521 ns521 0 1e-12
Ca522 ns522 0 1e-12
Ra521 ns521 0 719.606922067 noise=0
Ra522 ns522 0 719.606922067 noise=0
Ga521 ns521 0 ns522 0 -0.027902812344
Ga522 ns522 0 ns521 0 0.027902812344
Ca523 ns523 0 1e-12
Ca524 ns524 0 1e-12
Ra523 ns523 0 868.71266533 noise=0
Ra524 ns524 0 868.71266533 noise=0
Ga523 ns523 0 ns524 0 -0.027105710132
Ga524 ns524 0 ns523 0 0.027105710132
Ca525 ns525 0 1e-12
Ca526 ns526 0 1e-12
Ra525 ns525 0 2839.48624926 noise=0
Ra526 ns526 0 2839.48624926 noise=0
Ga525 ns525 0 ns526 0 -0.0273663668076
Ga526 ns526 0 ns525 0 0.0273663668076
Ca527 ns527 0 1e-12
Ca528 ns528 0 1e-12
Ra527 ns527 0 1673.32761037 noise=0
Ra528 ns528 0 1673.32761037 noise=0
Ga527 ns527 0 ns528 0 -0.0258400591067
Ga528 ns528 0 ns527 0 0.0258400591067
Ca529 ns529 0 1e-12
Ca530 ns530 0 1e-12
Ra529 ns529 0 1484.37908566 noise=0
Ra530 ns530 0 1484.37908566 noise=0
Ga529 ns529 0 ns530 0 -0.025495699249
Ga530 ns530 0 ns529 0 0.025495699249
Ca531 ns531 0 1e-12
Ca532 ns532 0 1e-12
Ra531 ns531 0 506.028775389 noise=0
Ra532 ns532 0 506.028775389 noise=0
Ga531 ns531 0 ns532 0 -0.0244848458169
Ga532 ns532 0 ns531 0 0.0244848458169
Ca533 ns533 0 1e-12
Ca534 ns534 0 1e-12
Ra533 ns533 0 2403.73305872 noise=0
Ra534 ns534 0 2403.73305872 noise=0
Ga533 ns533 0 ns534 0 -0.0239731392386
Ga534 ns534 0 ns533 0 0.0239731392386
Ca535 ns535 0 1e-12
Ca536 ns536 0 1e-12
Ra535 ns535 0 336.720349191 noise=0
Ra536 ns536 0 336.720349191 noise=0
Ga535 ns535 0 ns536 0 -0.00305921925757
Ga536 ns536 0 ns535 0 0.00305921925757
Ca537 ns537 0 1e-12
Ra537 ns537 0 625.504211572 noise=0
Ca538 ns538 0 1e-12
Ca539 ns539 0 1e-12
Ra538 ns538 0 430.146675815 noise=0
Ra539 ns539 0 430.146675815 noise=0
Ga538 ns538 0 ns539 0 -0.00415320581989
Ga539 ns539 0 ns538 0 0.00415320581989
Ca540 ns540 0 1e-12
Ra540 ns540 0 17951.6203469 noise=0
Ca541 ns541 0 1e-12
Ca542 ns542 0 1e-12
Ra541 ns541 0 2821.37654478 noise=0
Ra542 ns542 0 2821.37654478 noise=0
Ga541 ns541 0 ns542 0 -0.0232374996199
Ga542 ns542 0 ns541 0 0.0232374996199
Ca543 ns543 0 1e-12
Ca544 ns544 0 1e-12
Ra543 ns543 0 67461.356792 noise=0
Ra544 ns544 0 67461.356792 noise=0
Ga543 ns543 0 ns544 0 -0.0231359324144
Ga544 ns544 0 ns543 0 0.0231359324144
Ca545 ns545 0 1e-12
Ca546 ns546 0 1e-12
Ra545 ns545 0 3882.52713252 noise=0
Ra546 ns546 0 3882.52713252 noise=0
Ga545 ns545 0 ns546 0 -0.0222270795019
Ga546 ns546 0 ns545 0 0.0222270795019
Ca547 ns547 0 1e-12
Ca548 ns548 0 1e-12
Ra547 ns547 0 758.263705618 noise=0
Ra548 ns548 0 758.263705618 noise=0
Ga547 ns547 0 ns548 0 -0.0209094247609
Ga548 ns548 0 ns547 0 0.0209094247609
Ca549 ns549 0 1e-12
Ca550 ns550 0 1e-12
Ra549 ns549 0 8350.80403723 noise=0
Ra550 ns550 0 8350.80403723 noise=0
Ga549 ns549 0 ns550 0 -0.0213852085752
Ga550 ns550 0 ns549 0 0.0213852085752
Ca551 ns551 0 1e-12
Ca552 ns552 0 1e-12
Ra551 ns551 0 616.174027864 noise=0
Ra552 ns552 0 616.174027864 noise=0
Ga551 ns551 0 ns552 0 -0.00740609272703
Ga552 ns552 0 ns551 0 0.00740609272703
Ca553 ns553 0 1e-12
Ca554 ns554 0 1e-12
Ra553 ns553 0 2240.8902644 noise=0
Ra554 ns554 0 2240.8902644 noise=0
Ga553 ns553 0 ns554 0 -0.00746772306658
Ga554 ns554 0 ns553 0 0.00746772306658
Ca555 ns555 0 1e-12
Ca556 ns556 0 1e-12
Ra555 ns555 0 1715.78726301 noise=0
Ra556 ns556 0 1715.78726301 noise=0
Ga555 ns555 0 ns556 0 -0.0202800924869
Ga556 ns556 0 ns555 0 0.0202800924869
Ca557 ns557 0 1e-12
Ca558 ns558 0 1e-12
Ra557 ns557 0 408.27780973 noise=0
Ra558 ns558 0 408.27780973 noise=0
Ga557 ns557 0 ns558 0 -0.0179592042053
Ga558 ns558 0 ns557 0 0.0179592042053
Ca559 ns559 0 1e-12
Ca560 ns560 0 1e-12
Ra559 ns559 0 374.088130682 noise=0
Ra560 ns560 0 374.088130682 noise=0
Ga559 ns559 0 ns560 0 -0.0103669856253
Ga560 ns560 0 ns559 0 0.0103669856253
Ca561 ns561 0 1e-12
Ca562 ns562 0 1e-12
Ra561 ns561 0 1931.56177363 noise=0
Ra562 ns562 0 1931.56177363 noise=0
Ga561 ns561 0 ns562 0 -0.0193473747389
Ga562 ns562 0 ns561 0 0.0193473747389
Ca563 ns563 0 1e-12
Ca564 ns564 0 1e-12
Ra563 ns563 0 3071.79101237 noise=0
Ra564 ns564 0 3071.79101237 noise=0
Ga563 ns563 0 ns564 0 -0.00948551518969
Ga564 ns564 0 ns563 0 0.00948551518969
Ca565 ns565 0 1e-12
Ca566 ns566 0 1e-12
Ra565 ns565 0 2318.62067278 noise=0
Ra566 ns566 0 2318.62067278 noise=0
Ga565 ns565 0 ns566 0 -0.0185389316442
Ga566 ns566 0 ns565 0 0.0185389316442
Ca567 ns567 0 1e-12
Ca568 ns568 0 1e-12
Ra567 ns567 0 1261.43612591 noise=0
Ra568 ns568 0 1261.43612591 noise=0
Ga567 ns567 0 ns568 0 -0.0178219092867
Ga568 ns568 0 ns567 0 0.0178219092867
Ca569 ns569 0 1e-12
Ca570 ns570 0 1e-12
Ra569 ns569 0 589.61761212 noise=0
Ra570 ns570 0 589.61761212 noise=0
Ga569 ns569 0 ns570 0 -0.0124034071449
Ga570 ns570 0 ns569 0 0.0124034071449
Ca571 ns571 0 1e-12
Ca572 ns572 0 1e-12
Ra571 ns571 0 2088.12385991 noise=0
Ra572 ns572 0 2088.12385991 noise=0
Ga571 ns571 0 ns572 0 -0.0111604326344
Ga572 ns572 0 ns571 0 0.0111604326344
Ca573 ns573 0 1e-12
Ca574 ns574 0 1e-12
Ra573 ns573 0 3207.80911543 noise=0
Ra574 ns574 0 3207.80911543 noise=0
Ga573 ns573 0 ns574 0 -0.0168742866353
Ga574 ns574 0 ns573 0 0.0168742866353
Ca575 ns575 0 1e-12
Ca576 ns576 0 1e-12
Ra575 ns575 0 4077.32891446 noise=0
Ra576 ns576 0 4077.32891446 noise=0
Ga575 ns575 0 ns576 0 -0.0164639858896
Ga576 ns576 0 ns575 0 0.0164639858896
Ca577 ns577 0 1e-12
Ca578 ns578 0 1e-12
Ra577 ns577 0 4241.11006396 noise=0
Ra578 ns578 0 4241.11006396 noise=0
Ga577 ns577 0 ns578 0 -0.0159909003183
Ga578 ns578 0 ns577 0 0.0159909003183
Ca579 ns579 0 1e-12
Ca580 ns580 0 1e-12
Ra579 ns579 0 3824.28113946 noise=0
Ra580 ns580 0 3824.28113946 noise=0
Ga579 ns579 0 ns580 0 -0.0155195341527
Ga580 ns580 0 ns579 0 0.0155195341527
Ca581 ns581 0 1e-12
Ca582 ns582 0 1e-12
Ra581 ns581 0 2553.4865242 noise=0
Ra582 ns582 0 2553.4865242 noise=0
Ga581 ns581 0 ns582 0 -0.0145648283781
Ga582 ns582 0 ns581 0 0.0145648283781
Ca583 ns583 0 1e-12
Ca584 ns584 0 1e-12
Ra583 ns583 0 3995.3178827 noise=0
Ra584 ns584 0 3995.3178827 noise=0
Ga583 ns583 0 ns584 0 -0.0139253464377
Ga584 ns584 0 ns583 0 0.0139253464377
Ca585 ns585 0 1e-12
Ca586 ns586 0 1e-12
Ra585 ns585 0 4285.29014898 noise=0
Ra586 ns586 0 4285.29014898 noise=0
Ga585 ns585 0 ns586 0 -0.0151661580471
Ga586 ns586 0 ns585 0 0.0151661580471
Ca587 ns587 0 1e-12
Ca588 ns588 0 1e-12
Ra587 ns587 0 16793.3894905 noise=0
Ra588 ns588 0 16793.3894905 noise=0
Ga587 ns587 0 ns588 0 -0.0167238409126
Ga588 ns588 0 ns587 0 0.0167238409126
Ca589 ns589 0 1e-12
Ca590 ns590 0 1e-12
Ra589 ns589 0 3103.81445853 noise=0
Ra590 ns590 0 3103.81445853 noise=0
Ga589 ns589 0 ns590 0 -0.0128945863849
Ga590 ns590 0 ns589 0 0.0128945863849
Ca591 ns591 0 1e-12
Ca592 ns592 0 1e-12
Ra591 ns591 0 14690.330493 noise=0
Ra592 ns592 0 14690.330493 noise=0
Ga591 ns591 0 ns592 0 -0.0120032991301
Ga592 ns592 0 ns591 0 0.0120032991301
Ca593 ns593 0 1e-12
Ca594 ns594 0 1e-12
Ra593 ns593 0 96454.4614957 noise=0
Ra594 ns594 0 96454.4614957 noise=0
Ga593 ns593 0 ns594 0 -0.0119009664267
Ga594 ns594 0 ns593 0 0.0119009664267
Ca595 ns595 0 1e-12
Ca596 ns596 0 1e-12
Ra595 ns595 0 10342.4092713 noise=0
Ra596 ns596 0 10342.4092713 noise=0
Ga595 ns595 0 ns596 0 -0.0122370663137
Ga596 ns596 0 ns595 0 0.0122370663137
Ca597 ns597 0 1e-12
Ca598 ns598 0 1e-12
Ra597 ns597 0 8918.34391013 noise=0
Ra598 ns598 0 8918.34391013 noise=0
Ga597 ns597 0 ns598 0 -0.0126805471413
Ga598 ns598 0 ns597 0 0.0126805471413
Ca599 ns599 0 1e-12
Ca600 ns600 0 1e-12
Ra599 ns599 0 14042.6523429 noise=0
Ra600 ns600 0 14042.6523429 noise=0
Ga599 ns599 0 ns600 0 -0.012900675391
Ga600 ns600 0 ns599 0 0.012900675391
Ca601 ns601 0 1e-12
Ca602 ns602 0 1e-12
Ra601 ns601 0 8.25083067625 noise=0
Ra602 ns602 0 8.25083067625 noise=0
Ga601 ns601 0 ns602 0 -0.0427893075299
Ga602 ns602 0 ns601 0 0.0427893075299
Ca603 ns603 0 1e-12
Ca604 ns604 0 1e-12
Ra603 ns603 0 106.169491387 noise=0
Ra604 ns604 0 106.169491387 noise=0
Ga603 ns603 0 ns604 0 -0.0711386311877
Ga604 ns604 0 ns603 0 0.0711386311877
Ca605 ns605 0 1e-12
Ca606 ns606 0 1e-12
Ra605 ns605 0 714.164477404 noise=0
Ra606 ns606 0 714.164477404 noise=0
Ga605 ns605 0 ns606 0 -0.0649673770601
Ga606 ns606 0 ns605 0 0.0649673770601
Ca607 ns607 0 1e-12
Ca608 ns608 0 1e-12
Ra607 ns607 0 659.637590341 noise=0
Ra608 ns608 0 659.637590341 noise=0
Ga607 ns607 0 ns608 0 -0.0625850853995
Ga608 ns608 0 ns607 0 0.0625850853995
Ca609 ns609 0 1e-12
Ca610 ns610 0 1e-12
Ra609 ns609 0 27454.0019815 noise=0
Ra610 ns610 0 27454.0019815 noise=0
Ga609 ns609 0 ns610 0 -0.0617049463428
Ga610 ns610 0 ns609 0 0.0617049463428
Ca611 ns611 0 1e-12
Ca612 ns612 0 1e-12
Ra611 ns611 0 696.676751258 noise=0
Ra612 ns612 0 696.676751258 noise=0
Ga611 ns611 0 ns612 0 -0.0610299670021
Ga612 ns612 0 ns611 0 0.0610299670021
Ca613 ns613 0 1e-12
Ca614 ns614 0 1e-12
Ra613 ns613 0 944.255939097 noise=0
Ra614 ns614 0 944.255939097 noise=0
Ga613 ns613 0 ns614 0 -0.0596057773168
Ga614 ns614 0 ns613 0 0.0596057773168
Ca615 ns615 0 1e-12
Ca616 ns616 0 1e-12
Ra615 ns615 0 792.645910493 noise=0
Ra616 ns616 0 792.645910493 noise=0
Ga615 ns615 0 ns616 0 -0.0587366995705
Ga616 ns616 0 ns615 0 0.0587366995705
Ca617 ns617 0 1e-12
Ca618 ns618 0 1e-12
Ra617 ns617 0 667.745443679 noise=0
Ra618 ns618 0 667.745443679 noise=0
Ga617 ns617 0 ns618 0 -0.0571177908626
Ga618 ns618 0 ns617 0 0.0571177908626
Ca619 ns619 0 1e-12
Ca620 ns620 0 1e-12
Ra619 ns619 0 683.486879096 noise=0
Ra620 ns620 0 683.486879096 noise=0
Ga619 ns619 0 ns620 0 -0.0551711926529
Ga620 ns620 0 ns619 0 0.0551711926529
Ca621 ns621 0 1e-12
Ca622 ns622 0 1e-12
Ra621 ns621 0 862.471199603 noise=0
Ra622 ns622 0 862.471199603 noise=0
Ga621 ns621 0 ns622 0 -0.0543880261285
Ga622 ns622 0 ns621 0 0.0543880261285
Ca623 ns623 0 1e-12
Ca624 ns624 0 1e-12
Ra623 ns623 0 529.094552392 noise=0
Ra624 ns624 0 529.094552392 noise=0
Ga623 ns623 0 ns624 0 -0.0521921809837
Ga624 ns624 0 ns623 0 0.0521921809837
Ca625 ns625 0 1e-12
Ca626 ns626 0 1e-12
Ra625 ns625 0 1662.50489913 noise=0
Ra626 ns626 0 1662.50489913 noise=0
Ga625 ns625 0 ns626 0 -0.0518326775062
Ga626 ns626 0 ns625 0 0.0518326775062
Ca627 ns627 0 1e-12
Ca628 ns628 0 1e-12
Ra627 ns627 0 823.283626698 noise=0
Ra628 ns628 0 823.283626698 noise=0
Ga627 ns627 0 ns628 0 -0.0503365541484
Ga628 ns628 0 ns627 0 0.0503365541484
Ca629 ns629 0 1e-12
Ca630 ns630 0 1e-12
Ra629 ns629 0 498.747250885 noise=0
Ra630 ns630 0 498.747250885 noise=0
Ga629 ns629 0 ns630 0 -0.0480660213561
Ga630 ns630 0 ns629 0 0.0480660213561
Ca631 ns631 0 1e-12
Ca632 ns632 0 1e-12
Ra631 ns631 0 2400.34571746 noise=0
Ra632 ns632 0 2400.34571746 noise=0
Ga631 ns631 0 ns632 0 -0.0491541733443
Ga632 ns632 0 ns631 0 0.0491541733443
Ca633 ns633 0 1e-12
Ca634 ns634 0 1e-12
Ra633 ns633 0 1789.73820066 noise=0
Ra634 ns634 0 1789.73820066 noise=0
Ga633 ns633 0 ns634 0 -0.0472980535656
Ga634 ns634 0 ns633 0 0.0472980535656
Ca635 ns635 0 1e-12
Ca636 ns636 0 1e-12
Ra635 ns635 0 619.467180392 noise=0
Ra636 ns636 0 619.467180392 noise=0
Ga635 ns635 0 ns636 0 -0.0454172104854
Ga636 ns636 0 ns635 0 0.0454172104854
Ca637 ns637 0 1e-12
Ca638 ns638 0 1e-12
Ra637 ns637 0 1515.47634345 noise=0
Ra638 ns638 0 1515.47634345 noise=0
Ga637 ns637 0 ns638 0 -0.045410084729
Ga638 ns638 0 ns637 0 0.045410084729
Ca639 ns639 0 1e-12
Ca640 ns640 0 1e-12
Ra639 ns639 0 1056.49405077 noise=0
Ra640 ns640 0 1056.49405077 noise=0
Ga639 ns639 0 ns640 0 -0.04352518111
Ga640 ns640 0 ns639 0 0.04352518111
Ca641 ns641 0 1e-12
Ca642 ns642 0 1e-12
Ra641 ns641 0 584.380114574 noise=0
Ra642 ns642 0 584.380114574 noise=0
Ga641 ns641 0 ns642 0 -0.0420110127096
Ga642 ns642 0 ns641 0 0.0420110127096
Ca643 ns643 0 1e-12
Ca644 ns644 0 1e-12
Ra643 ns643 0 1100.37898121 noise=0
Ra644 ns644 0 1100.37898121 noise=0
Ga643 ns643 0 ns644 0 -0.0421057924028
Ga644 ns644 0 ns643 0 0.0421057924028
Ca645 ns645 0 1e-12
Ca646 ns646 0 1e-12
Ra645 ns645 0 2151.05522891 noise=0
Ra646 ns646 0 2151.05522891 noise=0
Ga645 ns645 0 ns646 0 -0.0411613399603
Ga646 ns646 0 ns645 0 0.0411613399603
Ca647 ns647 0 1e-12
Ca648 ns648 0 1e-12
Ra647 ns647 0 925.931226012 noise=0
Ra648 ns648 0 925.931226012 noise=0
Ga647 ns647 0 ns648 0 -0.0394771715126
Ga648 ns648 0 ns647 0 0.0394771715126
Ca649 ns649 0 1e-12
Ca650 ns650 0 1e-12
Ra649 ns649 0 1418.8089157 noise=0
Ra650 ns650 0 1418.8089157 noise=0
Ga649 ns649 0 ns650 0 -0.0387605133287
Ga650 ns650 0 ns649 0 0.0387605133287
Ca651 ns651 0 1e-12
Ca652 ns652 0 1e-12
Ra651 ns651 0 915.223062825 noise=0
Ra652 ns652 0 915.223062825 noise=0
Ga651 ns651 0 ns652 0 -0.0375772253735
Ga652 ns652 0 ns651 0 0.0375772253735
Ca653 ns653 0 1e-12
Ca654 ns654 0 1e-12
Ra653 ns653 0 840.127812543 noise=0
Ra654 ns654 0 840.127812543 noise=0
Ga653 ns653 0 ns654 0 -0.0364938165135
Ga654 ns654 0 ns653 0 0.0364938165135
Ca655 ns655 0 1e-12
Ca656 ns656 0 1e-12
Ra655 ns655 0 652.300622951 noise=0
Ra656 ns656 0 652.300622951 noise=0
Ga655 ns655 0 ns656 0 -0.0345758138052
Ga656 ns656 0 ns655 0 0.0345758138052
Ca657 ns657 0 1e-12
Ca658 ns658 0 1e-12
Ra657 ns657 0 1514.05417225 noise=0
Ra658 ns658 0 1514.05417225 noise=0
Ga657 ns657 0 ns658 0 -0.0349101368215
Ga658 ns658 0 ns657 0 0.0349101368215
Ca659 ns659 0 1e-12
Ca660 ns660 0 1e-12
Ra659 ns659 0 2090.57622699 noise=0
Ra660 ns660 0 2090.57622699 noise=0
Ga659 ns659 0 ns660 0 -0.0330272390634
Ga660 ns660 0 ns659 0 0.0330272390634
Ca661 ns661 0 1e-12
Ca662 ns662 0 1e-12
Ra661 ns661 0 1332.31293014 noise=0
Ra662 ns662 0 1332.31293014 noise=0
Ga661 ns661 0 ns662 0 -0.0327912251637
Ga662 ns662 0 ns661 0 0.0327912251637
Ca663 ns663 0 1e-12
Ca664 ns664 0 1e-12
Ra663 ns663 0 562.450005592 noise=0
Ra664 ns664 0 562.450005592 noise=0
Ga663 ns663 0 ns664 0 -0.031824332533
Ga664 ns664 0 ns663 0 0.031824332533
Ca665 ns665 0 1e-12
Ca666 ns666 0 1e-12
Ra665 ns665 0 2569.70403351 noise=0
Ra666 ns666 0 2569.70403351 noise=0
Ga665 ns665 0 ns666 0 -0.0308554267187
Ga666 ns666 0 ns665 0 0.0308554267187
Ca667 ns667 0 1e-12
Ca668 ns668 0 1e-12
Ra667 ns667 0 1611.59888007 noise=0
Ra668 ns668 0 1611.59888007 noise=0
Ga667 ns667 0 ns668 0 -0.0300762531925
Ga668 ns668 0 ns667 0 0.0300762531925
Ca669 ns669 0 1e-12
Ca670 ns670 0 1e-12
Ra669 ns669 0 9772.30555598 noise=0
Ra670 ns670 0 9772.30555598 noise=0
Ga669 ns669 0 ns670 0 -0.0293102987233
Ga670 ns670 0 ns669 0 0.0293102987233
Ca671 ns671 0 1e-12
Ca672 ns672 0 1e-12
Ra671 ns671 0 719.606922067 noise=0
Ra672 ns672 0 719.606922067 noise=0
Ga671 ns671 0 ns672 0 -0.027902812344
Ga672 ns672 0 ns671 0 0.027902812344
Ca673 ns673 0 1e-12
Ca674 ns674 0 1e-12
Ra673 ns673 0 868.71266533 noise=0
Ra674 ns674 0 868.71266533 noise=0
Ga673 ns673 0 ns674 0 -0.027105710132
Ga674 ns674 0 ns673 0 0.027105710132
Ca675 ns675 0 1e-12
Ca676 ns676 0 1e-12
Ra675 ns675 0 2839.48624926 noise=0
Ra676 ns676 0 2839.48624926 noise=0
Ga675 ns675 0 ns676 0 -0.0273663668076
Ga676 ns676 0 ns675 0 0.0273663668076
Ca677 ns677 0 1e-12
Ca678 ns678 0 1e-12
Ra677 ns677 0 1673.32761037 noise=0
Ra678 ns678 0 1673.32761037 noise=0
Ga677 ns677 0 ns678 0 -0.0258400591067
Ga678 ns678 0 ns677 0 0.0258400591067
Ca679 ns679 0 1e-12
Ca680 ns680 0 1e-12
Ra679 ns679 0 1484.37908566 noise=0
Ra680 ns680 0 1484.37908566 noise=0
Ga679 ns679 0 ns680 0 -0.025495699249
Ga680 ns680 0 ns679 0 0.025495699249
Ca681 ns681 0 1e-12
Ca682 ns682 0 1e-12
Ra681 ns681 0 506.028775389 noise=0
Ra682 ns682 0 506.028775389 noise=0
Ga681 ns681 0 ns682 0 -0.0244848458169
Ga682 ns682 0 ns681 0 0.0244848458169
Ca683 ns683 0 1e-12
Ca684 ns684 0 1e-12
Ra683 ns683 0 2403.73305872 noise=0
Ra684 ns684 0 2403.73305872 noise=0
Ga683 ns683 0 ns684 0 -0.0239731392386
Ga684 ns684 0 ns683 0 0.0239731392386
Ca685 ns685 0 1e-12
Ca686 ns686 0 1e-12
Ra685 ns685 0 336.720349191 noise=0
Ra686 ns686 0 336.720349191 noise=0
Ga685 ns685 0 ns686 0 -0.00305921925757
Ga686 ns686 0 ns685 0 0.00305921925757
Ca687 ns687 0 1e-12
Ra687 ns687 0 625.504211572 noise=0
Ca688 ns688 0 1e-12
Ca689 ns689 0 1e-12
Ra688 ns688 0 430.146675815 noise=0
Ra689 ns689 0 430.146675815 noise=0
Ga688 ns688 0 ns689 0 -0.00415320581989
Ga689 ns689 0 ns688 0 0.00415320581989
Ca690 ns690 0 1e-12
Ra690 ns690 0 17951.6203469 noise=0
Ca691 ns691 0 1e-12
Ca692 ns692 0 1e-12
Ra691 ns691 0 2821.37654478 noise=0
Ra692 ns692 0 2821.37654478 noise=0
Ga691 ns691 0 ns692 0 -0.0232374996199
Ga692 ns692 0 ns691 0 0.0232374996199
Ca693 ns693 0 1e-12
Ca694 ns694 0 1e-12
Ra693 ns693 0 67461.356792 noise=0
Ra694 ns694 0 67461.356792 noise=0
Ga693 ns693 0 ns694 0 -0.0231359324144
Ga694 ns694 0 ns693 0 0.0231359324144
Ca695 ns695 0 1e-12
Ca696 ns696 0 1e-12
Ra695 ns695 0 3882.52713252 noise=0
Ra696 ns696 0 3882.52713252 noise=0
Ga695 ns695 0 ns696 0 -0.0222270795019
Ga696 ns696 0 ns695 0 0.0222270795019
Ca697 ns697 0 1e-12
Ca698 ns698 0 1e-12
Ra697 ns697 0 758.263705618 noise=0
Ra698 ns698 0 758.263705618 noise=0
Ga697 ns697 0 ns698 0 -0.0209094247609
Ga698 ns698 0 ns697 0 0.0209094247609
Ca699 ns699 0 1e-12
Ca700 ns700 0 1e-12
Ra699 ns699 0 8350.80403723 noise=0
Ra700 ns700 0 8350.80403723 noise=0
Ga699 ns699 0 ns700 0 -0.0213852085752
Ga700 ns700 0 ns699 0 0.0213852085752
Ca701 ns701 0 1e-12
Ca702 ns702 0 1e-12
Ra701 ns701 0 616.174027864 noise=0
Ra702 ns702 0 616.174027864 noise=0
Ga701 ns701 0 ns702 0 -0.00740609272703
Ga702 ns702 0 ns701 0 0.00740609272703
Ca703 ns703 0 1e-12
Ca704 ns704 0 1e-12
Ra703 ns703 0 2240.8902644 noise=0
Ra704 ns704 0 2240.8902644 noise=0
Ga703 ns703 0 ns704 0 -0.00746772306658
Ga704 ns704 0 ns703 0 0.00746772306658
Ca705 ns705 0 1e-12
Ca706 ns706 0 1e-12
Ra705 ns705 0 1715.78726301 noise=0
Ra706 ns706 0 1715.78726301 noise=0
Ga705 ns705 0 ns706 0 -0.0202800924869
Ga706 ns706 0 ns705 0 0.0202800924869
Ca707 ns707 0 1e-12
Ca708 ns708 0 1e-12
Ra707 ns707 0 408.27780973 noise=0
Ra708 ns708 0 408.27780973 noise=0
Ga707 ns707 0 ns708 0 -0.0179592042053
Ga708 ns708 0 ns707 0 0.0179592042053
Ca709 ns709 0 1e-12
Ca710 ns710 0 1e-12
Ra709 ns709 0 374.088130682 noise=0
Ra710 ns710 0 374.088130682 noise=0
Ga709 ns709 0 ns710 0 -0.0103669856253
Ga710 ns710 0 ns709 0 0.0103669856253
Ca711 ns711 0 1e-12
Ca712 ns712 0 1e-12
Ra711 ns711 0 1931.56177363 noise=0
Ra712 ns712 0 1931.56177363 noise=0
Ga711 ns711 0 ns712 0 -0.0193473747389
Ga712 ns712 0 ns711 0 0.0193473747389
Ca713 ns713 0 1e-12
Ca714 ns714 0 1e-12
Ra713 ns713 0 3071.79101237 noise=0
Ra714 ns714 0 3071.79101237 noise=0
Ga713 ns713 0 ns714 0 -0.00948551518969
Ga714 ns714 0 ns713 0 0.00948551518969
Ca715 ns715 0 1e-12
Ca716 ns716 0 1e-12
Ra715 ns715 0 2318.62067278 noise=0
Ra716 ns716 0 2318.62067278 noise=0
Ga715 ns715 0 ns716 0 -0.0185389316442
Ga716 ns716 0 ns715 0 0.0185389316442
Ca717 ns717 0 1e-12
Ca718 ns718 0 1e-12
Ra717 ns717 0 1261.43612591 noise=0
Ra718 ns718 0 1261.43612591 noise=0
Ga717 ns717 0 ns718 0 -0.0178219092867
Ga718 ns718 0 ns717 0 0.0178219092867
Ca719 ns719 0 1e-12
Ca720 ns720 0 1e-12
Ra719 ns719 0 589.61761212 noise=0
Ra720 ns720 0 589.61761212 noise=0
Ga719 ns719 0 ns720 0 -0.0124034071449
Ga720 ns720 0 ns719 0 0.0124034071449
Ca721 ns721 0 1e-12
Ca722 ns722 0 1e-12
Ra721 ns721 0 2088.12385991 noise=0
Ra722 ns722 0 2088.12385991 noise=0
Ga721 ns721 0 ns722 0 -0.0111604326344
Ga722 ns722 0 ns721 0 0.0111604326344
Ca723 ns723 0 1e-12
Ca724 ns724 0 1e-12
Ra723 ns723 0 3207.80911543 noise=0
Ra724 ns724 0 3207.80911543 noise=0
Ga723 ns723 0 ns724 0 -0.0168742866353
Ga724 ns724 0 ns723 0 0.0168742866353
Ca725 ns725 0 1e-12
Ca726 ns726 0 1e-12
Ra725 ns725 0 4077.32891446 noise=0
Ra726 ns726 0 4077.32891446 noise=0
Ga725 ns725 0 ns726 0 -0.0164639858896
Ga726 ns726 0 ns725 0 0.0164639858896
Ca727 ns727 0 1e-12
Ca728 ns728 0 1e-12
Ra727 ns727 0 4241.11006396 noise=0
Ra728 ns728 0 4241.11006396 noise=0
Ga727 ns727 0 ns728 0 -0.0159909003183
Ga728 ns728 0 ns727 0 0.0159909003183
Ca729 ns729 0 1e-12
Ca730 ns730 0 1e-12
Ra729 ns729 0 3824.28113946 noise=0
Ra730 ns730 0 3824.28113946 noise=0
Ga729 ns729 0 ns730 0 -0.0155195341527
Ga730 ns730 0 ns729 0 0.0155195341527
Ca731 ns731 0 1e-12
Ca732 ns732 0 1e-12
Ra731 ns731 0 2553.4865242 noise=0
Ra732 ns732 0 2553.4865242 noise=0
Ga731 ns731 0 ns732 0 -0.0145648283781
Ga732 ns732 0 ns731 0 0.0145648283781
Ca733 ns733 0 1e-12
Ca734 ns734 0 1e-12
Ra733 ns733 0 3995.3178827 noise=0
Ra734 ns734 0 3995.3178827 noise=0
Ga733 ns733 0 ns734 0 -0.0139253464377
Ga734 ns734 0 ns733 0 0.0139253464377
Ca735 ns735 0 1e-12
Ca736 ns736 0 1e-12
Ra735 ns735 0 4285.29014898 noise=0
Ra736 ns736 0 4285.29014898 noise=0
Ga735 ns735 0 ns736 0 -0.0151661580471
Ga736 ns736 0 ns735 0 0.0151661580471
Ca737 ns737 0 1e-12
Ca738 ns738 0 1e-12
Ra737 ns737 0 16793.3894905 noise=0
Ra738 ns738 0 16793.3894905 noise=0
Ga737 ns737 0 ns738 0 -0.0167238409126
Ga738 ns738 0 ns737 0 0.0167238409126
Ca739 ns739 0 1e-12
Ca740 ns740 0 1e-12
Ra739 ns739 0 3103.81445853 noise=0
Ra740 ns740 0 3103.81445853 noise=0
Ga739 ns739 0 ns740 0 -0.0128945863849
Ga740 ns740 0 ns739 0 0.0128945863849
Ca741 ns741 0 1e-12
Ca742 ns742 0 1e-12
Ra741 ns741 0 14690.330493 noise=0
Ra742 ns742 0 14690.330493 noise=0
Ga741 ns741 0 ns742 0 -0.0120032991301
Ga742 ns742 0 ns741 0 0.0120032991301
Ca743 ns743 0 1e-12
Ca744 ns744 0 1e-12
Ra743 ns743 0 96454.4614957 noise=0
Ra744 ns744 0 96454.4614957 noise=0
Ga743 ns743 0 ns744 0 -0.0119009664267
Ga744 ns744 0 ns743 0 0.0119009664267
Ca745 ns745 0 1e-12
Ca746 ns746 0 1e-12
Ra745 ns745 0 10342.4092713 noise=0
Ra746 ns746 0 10342.4092713 noise=0
Ga745 ns745 0 ns746 0 -0.0122370663137
Ga746 ns746 0 ns745 0 0.0122370663137
Ca747 ns747 0 1e-12
Ca748 ns748 0 1e-12
Ra747 ns747 0 8918.34391013 noise=0
Ra748 ns748 0 8918.34391013 noise=0
Ga747 ns747 0 ns748 0 -0.0126805471413
Ga748 ns748 0 ns747 0 0.0126805471413
Ca749 ns749 0 1e-12
Ca750 ns750 0 1e-12
Ra749 ns749 0 14042.6523429 noise=0
Ra750 ns750 0 14042.6523429 noise=0
Ga749 ns749 0 ns750 0 -0.012900675391
Ga750 ns750 0 ns749 0 0.012900675391
Ca751 ns751 0 1e-12
Ca752 ns752 0 1e-12
Ra751 ns751 0 8.25083067625 noise=0
Ra752 ns752 0 8.25083067625 noise=0
Ga751 ns751 0 ns752 0 -0.0427893075299
Ga752 ns752 0 ns751 0 0.0427893075299
Ca753 ns753 0 1e-12
Ca754 ns754 0 1e-12
Ra753 ns753 0 106.169491387 noise=0
Ra754 ns754 0 106.169491387 noise=0
Ga753 ns753 0 ns754 0 -0.0711386311877
Ga754 ns754 0 ns753 0 0.0711386311877
Ca755 ns755 0 1e-12
Ca756 ns756 0 1e-12
Ra755 ns755 0 714.164477404 noise=0
Ra756 ns756 0 714.164477404 noise=0
Ga755 ns755 0 ns756 0 -0.0649673770601
Ga756 ns756 0 ns755 0 0.0649673770601
Ca757 ns757 0 1e-12
Ca758 ns758 0 1e-12
Ra757 ns757 0 659.637590341 noise=0
Ra758 ns758 0 659.637590341 noise=0
Ga757 ns757 0 ns758 0 -0.0625850853995
Ga758 ns758 0 ns757 0 0.0625850853995
Ca759 ns759 0 1e-12
Ca760 ns760 0 1e-12
Ra759 ns759 0 27454.0019815 noise=0
Ra760 ns760 0 27454.0019815 noise=0
Ga759 ns759 0 ns760 0 -0.0617049463428
Ga760 ns760 0 ns759 0 0.0617049463428
Ca761 ns761 0 1e-12
Ca762 ns762 0 1e-12
Ra761 ns761 0 696.676751258 noise=0
Ra762 ns762 0 696.676751258 noise=0
Ga761 ns761 0 ns762 0 -0.0610299670021
Ga762 ns762 0 ns761 0 0.0610299670021
Ca763 ns763 0 1e-12
Ca764 ns764 0 1e-12
Ra763 ns763 0 944.255939097 noise=0
Ra764 ns764 0 944.255939097 noise=0
Ga763 ns763 0 ns764 0 -0.0596057773168
Ga764 ns764 0 ns763 0 0.0596057773168
Ca765 ns765 0 1e-12
Ca766 ns766 0 1e-12
Ra765 ns765 0 792.645910493 noise=0
Ra766 ns766 0 792.645910493 noise=0
Ga765 ns765 0 ns766 0 -0.0587366995705
Ga766 ns766 0 ns765 0 0.0587366995705
Ca767 ns767 0 1e-12
Ca768 ns768 0 1e-12
Ra767 ns767 0 667.745443679 noise=0
Ra768 ns768 0 667.745443679 noise=0
Ga767 ns767 0 ns768 0 -0.0571177908626
Ga768 ns768 0 ns767 0 0.0571177908626
Ca769 ns769 0 1e-12
Ca770 ns770 0 1e-12
Ra769 ns769 0 683.486879096 noise=0
Ra770 ns770 0 683.486879096 noise=0
Ga769 ns769 0 ns770 0 -0.0551711926529
Ga770 ns770 0 ns769 0 0.0551711926529
Ca771 ns771 0 1e-12
Ca772 ns772 0 1e-12
Ra771 ns771 0 862.471199603 noise=0
Ra772 ns772 0 862.471199603 noise=0
Ga771 ns771 0 ns772 0 -0.0543880261285
Ga772 ns772 0 ns771 0 0.0543880261285
Ca773 ns773 0 1e-12
Ca774 ns774 0 1e-12
Ra773 ns773 0 529.094552392 noise=0
Ra774 ns774 0 529.094552392 noise=0
Ga773 ns773 0 ns774 0 -0.0521921809837
Ga774 ns774 0 ns773 0 0.0521921809837
Ca775 ns775 0 1e-12
Ca776 ns776 0 1e-12
Ra775 ns775 0 1662.50489913 noise=0
Ra776 ns776 0 1662.50489913 noise=0
Ga775 ns775 0 ns776 0 -0.0518326775062
Ga776 ns776 0 ns775 0 0.0518326775062
Ca777 ns777 0 1e-12
Ca778 ns778 0 1e-12
Ra777 ns777 0 823.283626698 noise=0
Ra778 ns778 0 823.283626698 noise=0
Ga777 ns777 0 ns778 0 -0.0503365541484
Ga778 ns778 0 ns777 0 0.0503365541484
Ca779 ns779 0 1e-12
Ca780 ns780 0 1e-12
Ra779 ns779 0 498.747250885 noise=0
Ra780 ns780 0 498.747250885 noise=0
Ga779 ns779 0 ns780 0 -0.0480660213561
Ga780 ns780 0 ns779 0 0.0480660213561
Ca781 ns781 0 1e-12
Ca782 ns782 0 1e-12
Ra781 ns781 0 2400.34571746 noise=0
Ra782 ns782 0 2400.34571746 noise=0
Ga781 ns781 0 ns782 0 -0.0491541733443
Ga782 ns782 0 ns781 0 0.0491541733443
Ca783 ns783 0 1e-12
Ca784 ns784 0 1e-12
Ra783 ns783 0 1789.73820066 noise=0
Ra784 ns784 0 1789.73820066 noise=0
Ga783 ns783 0 ns784 0 -0.0472980535656
Ga784 ns784 0 ns783 0 0.0472980535656
Ca785 ns785 0 1e-12
Ca786 ns786 0 1e-12
Ra785 ns785 0 619.467180392 noise=0
Ra786 ns786 0 619.467180392 noise=0
Ga785 ns785 0 ns786 0 -0.0454172104854
Ga786 ns786 0 ns785 0 0.0454172104854
Ca787 ns787 0 1e-12
Ca788 ns788 0 1e-12
Ra787 ns787 0 1515.47634345 noise=0
Ra788 ns788 0 1515.47634345 noise=0
Ga787 ns787 0 ns788 0 -0.045410084729
Ga788 ns788 0 ns787 0 0.045410084729
Ca789 ns789 0 1e-12
Ca790 ns790 0 1e-12
Ra789 ns789 0 1056.49405077 noise=0
Ra790 ns790 0 1056.49405077 noise=0
Ga789 ns789 0 ns790 0 -0.04352518111
Ga790 ns790 0 ns789 0 0.04352518111
Ca791 ns791 0 1e-12
Ca792 ns792 0 1e-12
Ra791 ns791 0 584.380114574 noise=0
Ra792 ns792 0 584.380114574 noise=0
Ga791 ns791 0 ns792 0 -0.0420110127096
Ga792 ns792 0 ns791 0 0.0420110127096
Ca793 ns793 0 1e-12
Ca794 ns794 0 1e-12
Ra793 ns793 0 1100.37898121 noise=0
Ra794 ns794 0 1100.37898121 noise=0
Ga793 ns793 0 ns794 0 -0.0421057924028
Ga794 ns794 0 ns793 0 0.0421057924028
Ca795 ns795 0 1e-12
Ca796 ns796 0 1e-12
Ra795 ns795 0 2151.05522891 noise=0
Ra796 ns796 0 2151.05522891 noise=0
Ga795 ns795 0 ns796 0 -0.0411613399603
Ga796 ns796 0 ns795 0 0.0411613399603
Ca797 ns797 0 1e-12
Ca798 ns798 0 1e-12
Ra797 ns797 0 925.931226012 noise=0
Ra798 ns798 0 925.931226012 noise=0
Ga797 ns797 0 ns798 0 -0.0394771715126
Ga798 ns798 0 ns797 0 0.0394771715126
Ca799 ns799 0 1e-12
Ca800 ns800 0 1e-12
Ra799 ns799 0 1418.8089157 noise=0
Ra800 ns800 0 1418.8089157 noise=0
Ga799 ns799 0 ns800 0 -0.0387605133287
Ga800 ns800 0 ns799 0 0.0387605133287
Ca801 ns801 0 1e-12
Ca802 ns802 0 1e-12
Ra801 ns801 0 915.223062825 noise=0
Ra802 ns802 0 915.223062825 noise=0
Ga801 ns801 0 ns802 0 -0.0375772253735
Ga802 ns802 0 ns801 0 0.0375772253735
Ca803 ns803 0 1e-12
Ca804 ns804 0 1e-12
Ra803 ns803 0 840.127812543 noise=0
Ra804 ns804 0 840.127812543 noise=0
Ga803 ns803 0 ns804 0 -0.0364938165135
Ga804 ns804 0 ns803 0 0.0364938165135
Ca805 ns805 0 1e-12
Ca806 ns806 0 1e-12
Ra805 ns805 0 652.300622951 noise=0
Ra806 ns806 0 652.300622951 noise=0
Ga805 ns805 0 ns806 0 -0.0345758138052
Ga806 ns806 0 ns805 0 0.0345758138052
Ca807 ns807 0 1e-12
Ca808 ns808 0 1e-12
Ra807 ns807 0 1514.05417225 noise=0
Ra808 ns808 0 1514.05417225 noise=0
Ga807 ns807 0 ns808 0 -0.0349101368215
Ga808 ns808 0 ns807 0 0.0349101368215
Ca809 ns809 0 1e-12
Ca810 ns810 0 1e-12
Ra809 ns809 0 2090.57622699 noise=0
Ra810 ns810 0 2090.57622699 noise=0
Ga809 ns809 0 ns810 0 -0.0330272390634
Ga810 ns810 0 ns809 0 0.0330272390634
Ca811 ns811 0 1e-12
Ca812 ns812 0 1e-12
Ra811 ns811 0 1332.31293014 noise=0
Ra812 ns812 0 1332.31293014 noise=0
Ga811 ns811 0 ns812 0 -0.0327912251637
Ga812 ns812 0 ns811 0 0.0327912251637
Ca813 ns813 0 1e-12
Ca814 ns814 0 1e-12
Ra813 ns813 0 562.450005592 noise=0
Ra814 ns814 0 562.450005592 noise=0
Ga813 ns813 0 ns814 0 -0.031824332533
Ga814 ns814 0 ns813 0 0.031824332533
Ca815 ns815 0 1e-12
Ca816 ns816 0 1e-12
Ra815 ns815 0 2569.70403351 noise=0
Ra816 ns816 0 2569.70403351 noise=0
Ga815 ns815 0 ns816 0 -0.0308554267187
Ga816 ns816 0 ns815 0 0.0308554267187
Ca817 ns817 0 1e-12
Ca818 ns818 0 1e-12
Ra817 ns817 0 1611.59888007 noise=0
Ra818 ns818 0 1611.59888007 noise=0
Ga817 ns817 0 ns818 0 -0.0300762531925
Ga818 ns818 0 ns817 0 0.0300762531925
Ca819 ns819 0 1e-12
Ca820 ns820 0 1e-12
Ra819 ns819 0 9772.30555598 noise=0
Ra820 ns820 0 9772.30555598 noise=0
Ga819 ns819 0 ns820 0 -0.0293102987233
Ga820 ns820 0 ns819 0 0.0293102987233
Ca821 ns821 0 1e-12
Ca822 ns822 0 1e-12
Ra821 ns821 0 719.606922067 noise=0
Ra822 ns822 0 719.606922067 noise=0
Ga821 ns821 0 ns822 0 -0.027902812344
Ga822 ns822 0 ns821 0 0.027902812344
Ca823 ns823 0 1e-12
Ca824 ns824 0 1e-12
Ra823 ns823 0 868.71266533 noise=0
Ra824 ns824 0 868.71266533 noise=0
Ga823 ns823 0 ns824 0 -0.027105710132
Ga824 ns824 0 ns823 0 0.027105710132
Ca825 ns825 0 1e-12
Ca826 ns826 0 1e-12
Ra825 ns825 0 2839.48624926 noise=0
Ra826 ns826 0 2839.48624926 noise=0
Ga825 ns825 0 ns826 0 -0.0273663668076
Ga826 ns826 0 ns825 0 0.0273663668076
Ca827 ns827 0 1e-12
Ca828 ns828 0 1e-12
Ra827 ns827 0 1673.32761037 noise=0
Ra828 ns828 0 1673.32761037 noise=0
Ga827 ns827 0 ns828 0 -0.0258400591067
Ga828 ns828 0 ns827 0 0.0258400591067
Ca829 ns829 0 1e-12
Ca830 ns830 0 1e-12
Ra829 ns829 0 1484.37908566 noise=0
Ra830 ns830 0 1484.37908566 noise=0
Ga829 ns829 0 ns830 0 -0.025495699249
Ga830 ns830 0 ns829 0 0.025495699249
Ca831 ns831 0 1e-12
Ca832 ns832 0 1e-12
Ra831 ns831 0 506.028775389 noise=0
Ra832 ns832 0 506.028775389 noise=0
Ga831 ns831 0 ns832 0 -0.0244848458169
Ga832 ns832 0 ns831 0 0.0244848458169
Ca833 ns833 0 1e-12
Ca834 ns834 0 1e-12
Ra833 ns833 0 2403.73305872 noise=0
Ra834 ns834 0 2403.73305872 noise=0
Ga833 ns833 0 ns834 0 -0.0239731392386
Ga834 ns834 0 ns833 0 0.0239731392386
Ca835 ns835 0 1e-12
Ca836 ns836 0 1e-12
Ra835 ns835 0 336.720349191 noise=0
Ra836 ns836 0 336.720349191 noise=0
Ga835 ns835 0 ns836 0 -0.00305921925757
Ga836 ns836 0 ns835 0 0.00305921925757
Ca837 ns837 0 1e-12
Ra837 ns837 0 625.504211572 noise=0
Ca838 ns838 0 1e-12
Ca839 ns839 0 1e-12
Ra838 ns838 0 430.146675815 noise=0
Ra839 ns839 0 430.146675815 noise=0
Ga838 ns838 0 ns839 0 -0.00415320581989
Ga839 ns839 0 ns838 0 0.00415320581989
Ca840 ns840 0 1e-12
Ra840 ns840 0 17951.6203469 noise=0
Ca841 ns841 0 1e-12
Ca842 ns842 0 1e-12
Ra841 ns841 0 2821.37654478 noise=0
Ra842 ns842 0 2821.37654478 noise=0
Ga841 ns841 0 ns842 0 -0.0232374996199
Ga842 ns842 0 ns841 0 0.0232374996199
Ca843 ns843 0 1e-12
Ca844 ns844 0 1e-12
Ra843 ns843 0 67461.356792 noise=0
Ra844 ns844 0 67461.356792 noise=0
Ga843 ns843 0 ns844 0 -0.0231359324144
Ga844 ns844 0 ns843 0 0.0231359324144
Ca845 ns845 0 1e-12
Ca846 ns846 0 1e-12
Ra845 ns845 0 3882.52713252 noise=0
Ra846 ns846 0 3882.52713252 noise=0
Ga845 ns845 0 ns846 0 -0.0222270795019
Ga846 ns846 0 ns845 0 0.0222270795019
Ca847 ns847 0 1e-12
Ca848 ns848 0 1e-12
Ra847 ns847 0 758.263705618 noise=0
Ra848 ns848 0 758.263705618 noise=0
Ga847 ns847 0 ns848 0 -0.0209094247609
Ga848 ns848 0 ns847 0 0.0209094247609
Ca849 ns849 0 1e-12
Ca850 ns850 0 1e-12
Ra849 ns849 0 8350.80403723 noise=0
Ra850 ns850 0 8350.80403723 noise=0
Ga849 ns849 0 ns850 0 -0.0213852085752
Ga850 ns850 0 ns849 0 0.0213852085752
Ca851 ns851 0 1e-12
Ca852 ns852 0 1e-12
Ra851 ns851 0 616.174027864 noise=0
Ra852 ns852 0 616.174027864 noise=0
Ga851 ns851 0 ns852 0 -0.00740609272703
Ga852 ns852 0 ns851 0 0.00740609272703
Ca853 ns853 0 1e-12
Ca854 ns854 0 1e-12
Ra853 ns853 0 2240.8902644 noise=0
Ra854 ns854 0 2240.8902644 noise=0
Ga853 ns853 0 ns854 0 -0.00746772306658
Ga854 ns854 0 ns853 0 0.00746772306658
Ca855 ns855 0 1e-12
Ca856 ns856 0 1e-12
Ra855 ns855 0 1715.78726301 noise=0
Ra856 ns856 0 1715.78726301 noise=0
Ga855 ns855 0 ns856 0 -0.0202800924869
Ga856 ns856 0 ns855 0 0.0202800924869
Ca857 ns857 0 1e-12
Ca858 ns858 0 1e-12
Ra857 ns857 0 408.27780973 noise=0
Ra858 ns858 0 408.27780973 noise=0
Ga857 ns857 0 ns858 0 -0.0179592042053
Ga858 ns858 0 ns857 0 0.0179592042053
Ca859 ns859 0 1e-12
Ca860 ns860 0 1e-12
Ra859 ns859 0 374.088130682 noise=0
Ra860 ns860 0 374.088130682 noise=0
Ga859 ns859 0 ns860 0 -0.0103669856253
Ga860 ns860 0 ns859 0 0.0103669856253
Ca861 ns861 0 1e-12
Ca862 ns862 0 1e-12
Ra861 ns861 0 1931.56177363 noise=0
Ra862 ns862 0 1931.56177363 noise=0
Ga861 ns861 0 ns862 0 -0.0193473747389
Ga862 ns862 0 ns861 0 0.0193473747389
Ca863 ns863 0 1e-12
Ca864 ns864 0 1e-12
Ra863 ns863 0 3071.79101237 noise=0
Ra864 ns864 0 3071.79101237 noise=0
Ga863 ns863 0 ns864 0 -0.00948551518969
Ga864 ns864 0 ns863 0 0.00948551518969
Ca865 ns865 0 1e-12
Ca866 ns866 0 1e-12
Ra865 ns865 0 2318.62067278 noise=0
Ra866 ns866 0 2318.62067278 noise=0
Ga865 ns865 0 ns866 0 -0.0185389316442
Ga866 ns866 0 ns865 0 0.0185389316442
Ca867 ns867 0 1e-12
Ca868 ns868 0 1e-12
Ra867 ns867 0 1261.43612591 noise=0
Ra868 ns868 0 1261.43612591 noise=0
Ga867 ns867 0 ns868 0 -0.0178219092867
Ga868 ns868 0 ns867 0 0.0178219092867
Ca869 ns869 0 1e-12
Ca870 ns870 0 1e-12
Ra869 ns869 0 589.61761212 noise=0
Ra870 ns870 0 589.61761212 noise=0
Ga869 ns869 0 ns870 0 -0.0124034071449
Ga870 ns870 0 ns869 0 0.0124034071449
Ca871 ns871 0 1e-12
Ca872 ns872 0 1e-12
Ra871 ns871 0 2088.12385991 noise=0
Ra872 ns872 0 2088.12385991 noise=0
Ga871 ns871 0 ns872 0 -0.0111604326344
Ga872 ns872 0 ns871 0 0.0111604326344
Ca873 ns873 0 1e-12
Ca874 ns874 0 1e-12
Ra873 ns873 0 3207.80911543 noise=0
Ra874 ns874 0 3207.80911543 noise=0
Ga873 ns873 0 ns874 0 -0.0168742866353
Ga874 ns874 0 ns873 0 0.0168742866353
Ca875 ns875 0 1e-12
Ca876 ns876 0 1e-12
Ra875 ns875 0 4077.32891446 noise=0
Ra876 ns876 0 4077.32891446 noise=0
Ga875 ns875 0 ns876 0 -0.0164639858896
Ga876 ns876 0 ns875 0 0.0164639858896
Ca877 ns877 0 1e-12
Ca878 ns878 0 1e-12
Ra877 ns877 0 4241.11006396 noise=0
Ra878 ns878 0 4241.11006396 noise=0
Ga877 ns877 0 ns878 0 -0.0159909003183
Ga878 ns878 0 ns877 0 0.0159909003183
Ca879 ns879 0 1e-12
Ca880 ns880 0 1e-12
Ra879 ns879 0 3824.28113946 noise=0
Ra880 ns880 0 3824.28113946 noise=0
Ga879 ns879 0 ns880 0 -0.0155195341527
Ga880 ns880 0 ns879 0 0.0155195341527
Ca881 ns881 0 1e-12
Ca882 ns882 0 1e-12
Ra881 ns881 0 2553.4865242 noise=0
Ra882 ns882 0 2553.4865242 noise=0
Ga881 ns881 0 ns882 0 -0.0145648283781
Ga882 ns882 0 ns881 0 0.0145648283781
Ca883 ns883 0 1e-12
Ca884 ns884 0 1e-12
Ra883 ns883 0 3995.3178827 noise=0
Ra884 ns884 0 3995.3178827 noise=0
Ga883 ns883 0 ns884 0 -0.0139253464377
Ga884 ns884 0 ns883 0 0.0139253464377
Ca885 ns885 0 1e-12
Ca886 ns886 0 1e-12
Ra885 ns885 0 4285.29014898 noise=0
Ra886 ns886 0 4285.29014898 noise=0
Ga885 ns885 0 ns886 0 -0.0151661580471
Ga886 ns886 0 ns885 0 0.0151661580471
Ca887 ns887 0 1e-12
Ca888 ns888 0 1e-12
Ra887 ns887 0 16793.3894905 noise=0
Ra888 ns888 0 16793.3894905 noise=0
Ga887 ns887 0 ns888 0 -0.0167238409126
Ga888 ns888 0 ns887 0 0.0167238409126
Ca889 ns889 0 1e-12
Ca890 ns890 0 1e-12
Ra889 ns889 0 3103.81445853 noise=0
Ra890 ns890 0 3103.81445853 noise=0
Ga889 ns889 0 ns890 0 -0.0128945863849
Ga890 ns890 0 ns889 0 0.0128945863849
Ca891 ns891 0 1e-12
Ca892 ns892 0 1e-12
Ra891 ns891 0 14690.330493 noise=0
Ra892 ns892 0 14690.330493 noise=0
Ga891 ns891 0 ns892 0 -0.0120032991301
Ga892 ns892 0 ns891 0 0.0120032991301
Ca893 ns893 0 1e-12
Ca894 ns894 0 1e-12
Ra893 ns893 0 96454.4614957 noise=0
Ra894 ns894 0 96454.4614957 noise=0
Ga893 ns893 0 ns894 0 -0.0119009664267
Ga894 ns894 0 ns893 0 0.0119009664267
Ca895 ns895 0 1e-12
Ca896 ns896 0 1e-12
Ra895 ns895 0 10342.4092713 noise=0
Ra896 ns896 0 10342.4092713 noise=0
Ga895 ns895 0 ns896 0 -0.0122370663137
Ga896 ns896 0 ns895 0 0.0122370663137
Ca897 ns897 0 1e-12
Ca898 ns898 0 1e-12
Ra897 ns897 0 8918.34391013 noise=0
Ra898 ns898 0 8918.34391013 noise=0
Ga897 ns897 0 ns898 0 -0.0126805471413
Ga898 ns898 0 ns897 0 0.0126805471413
Ca899 ns899 0 1e-12
Ca900 ns900 0 1e-12
Ra899 ns899 0 14042.6523429 noise=0
Ra900 ns900 0 14042.6523429 noise=0
Ga899 ns899 0 ns900 0 -0.012900675391
Ga900 ns900 0 ns899 0 0.012900675391

Gb1_1 ns1 0 ni1 0 0.136306568658
Gb3_1 ns3 0 ni1 0 0.0723857132194
Gb5_1 ns5 0 ni1 0 0.0649975562917
Gb7_1 ns7 0 ni1 0 0.0626218067257
Gb9_1 ns9 0 ni1 0 0.0617049678443
Gb11_1 ns11 0 ni1 0 0.061063726364
Gb13_1 ns13 0 ni1 0 0.0596245935286
Gb15_1 ns15 0 ni1 0 0.0587637972445
Gb17_1 ns17 0 ni1 0 0.0571570559647
Gb19_1 ns19 0 ni1 0 0.0552099922543
Gb21_1 ns21 0 ni1 0 0.0544127437967
Gb23_1 ns23 0 ni1 0 0.0522606238162
Gb25_1 ns25 0 ni1 0 0.0518396577484
Gb27_1 ns27 0 ni1 0 0.0503658642661
Gb29_1 ns29 0 ni1 0 0.0481496588084
Gb31_1 ns31 0 ni1 0 0.0491577042979
Gb33_1 ns33 0 ni1 0 0.047304654079
Gb35_1 ns35 0 ni1 0 0.0454745881594
Gb37_1 ns37 0 ni1 0 0.0454196732002
Gb39_1 ns39 0 ni1 0 0.0435457648981
Gb41_1 ns41 0 ni1 0 0.0420807148302
Gb43_1 ns43 0 ni1 0 0.0421254067376
Gb45_1 ns45 0 ni1 0 0.0411665905414
Gb47_1 ns47 0 ni1 0 0.0395067173641
Gb49_1 ns49 0 ni1 0 0.0387733296286
Gb51_1 ns51 0 ni1 0 0.0376089956781
Gb53_1 ns53 0 ni1 0 0.0365326395939
Gb55_1 ns55 0 ni1 0 0.034643786111
Gb57_1 ns57 0 ni1 0 0.0349226326663
Gb59_1 ns59 0 ni1 0 0.0330341668694
Gb61_1 ns61 0 ni1 0 0.0328084054292
Gb63_1 ns63 0 ni1 0 0.0319236607971
Gb65_1 ns65 0 ni1 0 0.0308603346924
Gb67_1 ns67 0 ni1 0 0.0300890547365
Gb69_1 ns69 0 ni1 0 0.0293106559844
Gb71_1 ns71 0 ni1 0 0.0279720211501
Gb73_1 ns73 0 ni1 0 0.0271545964022
Gb75_1 ns75 0 ni1 0 0.0273708989476
Gb77_1 ns77 0 ni1 0 0.0258538802682
Gb79_1 ns79 0 ni1 0 0.0255135002088
Gb81_1 ns81 0 ni1 0 0.0246443426994
Gb83_1 ns83 0 ni1 0 0.0239803586638
Gb85_1 ns85 0 ni1 0 0.00594225926664
Gb87_1 ns87 0 ni1 0 0.00159871025886
Gb88_1 ns88 0 ni1 0 0.00545452372105
Gb90_1 ns90 0 ni1 0 5.57052778901e-05
Gb91_1 ns91 0 ni1 0 0.023242905775
Gb93_1 ns93 0 ni1 0 0.0231359419118
Gb95_1 ns95 0 ni1 0 0.0222300641188
Gb97_1 ns97 0 ni1 0 0.0209926044661
Gb99_1 ns99 0 ni1 0 0.0213858791233
Gb101_1 ns101 0 ni1 0 0.00776172738463
Gb103_1 ns103 0 ni1 0 0.00749438984893
Gb105_1 ns105 0 ni1 0 0.0202968420386
Gb107_1 ns107 0 ni1 0 0.0182932464234
Gb109_1 ns109 0 ni1 0 0.0110562719242
Gb111_1 ns111 0 ni1 0 0.0193612282785
Gb113_1 ns113 0 ni1 0 0.00949668782814
Gb115_1 ns115 0 ni1 0 0.0185489652236
Gb117_1 ns117 0 ni1 0 0.0178571719607
Gb119_1 ns119 0 ni1 0 0.0126353164129
Gb121_1 ns121 0 ni1 0 0.0111809823804
Gb123_1 ns123 0 ni1 0 0.016880045774
Gb125_1 ns125 0 ni1 0 0.0164676394267
Gb127_1 ns127 0 ni1 0 0.0159943770245
Gb129_1 ns129 0 ni1 0 0.0155239399215
Gb131_1 ns131 0 ni1 0 0.0145753583567
Gb133_1 ns133 0 ni1 0 0.0139298451821
Gb135_1 ns135 0 ni1 0 0.0151697486217
Gb137_1 ns137 0 ni1 0 0.0167240529377
Gb139_1 ns139 0 ni1 0 0.0129026364813
Gb141_1 ns141 0 ni1 0 0.0120036851736
Gb143_1 ns143 0 ni1 0 0.0119009754585
Gb145_1 ns145 0 ni1 0 0.0122378302889
Gb147_1 ns147 0 ni1 0 0.0126815386433
Gb149_1 ns149 0 ni1 0 0.0129010684786
Gb151_2 ns151 0 ni2 0 0.136306568658
Gb153_2 ns153 0 ni2 0 0.0723857132194
Gb155_2 ns155 0 ni2 0 0.0649975562917
Gb157_2 ns157 0 ni2 0 0.0626218067257
Gb159_2 ns159 0 ni2 0 0.0617049678443
Gb161_2 ns161 0 ni2 0 0.061063726364
Gb163_2 ns163 0 ni2 0 0.0596245935286
Gb165_2 ns165 0 ni2 0 0.0587637972445
Gb167_2 ns167 0 ni2 0 0.0571570559647
Gb169_2 ns169 0 ni2 0 0.0552099922543
Gb171_2 ns171 0 ni2 0 0.0544127437967
Gb173_2 ns173 0 ni2 0 0.0522606238162
Gb175_2 ns175 0 ni2 0 0.0518396577484
Gb177_2 ns177 0 ni2 0 0.0503658642661
Gb179_2 ns179 0 ni2 0 0.0481496588084
Gb181_2 ns181 0 ni2 0 0.0491577042979
Gb183_2 ns183 0 ni2 0 0.047304654079
Gb185_2 ns185 0 ni2 0 0.0454745881594
Gb187_2 ns187 0 ni2 0 0.0454196732002
Gb189_2 ns189 0 ni2 0 0.0435457648981
Gb191_2 ns191 0 ni2 0 0.0420807148302
Gb193_2 ns193 0 ni2 0 0.0421254067376
Gb195_2 ns195 0 ni2 0 0.0411665905414
Gb197_2 ns197 0 ni2 0 0.0395067173641
Gb199_2 ns199 0 ni2 0 0.0387733296286
Gb201_2 ns201 0 ni2 0 0.0376089956781
Gb203_2 ns203 0 ni2 0 0.0365326395939
Gb205_2 ns205 0 ni2 0 0.034643786111
Gb207_2 ns207 0 ni2 0 0.0349226326663
Gb209_2 ns209 0 ni2 0 0.0330341668694
Gb211_2 ns211 0 ni2 0 0.0328084054292
Gb213_2 ns213 0 ni2 0 0.0319236607971
Gb215_2 ns215 0 ni2 0 0.0308603346924
Gb217_2 ns217 0 ni2 0 0.0300890547365
Gb219_2 ns219 0 ni2 0 0.0293106559844
Gb221_2 ns221 0 ni2 0 0.0279720211501
Gb223_2 ns223 0 ni2 0 0.0271545964022
Gb225_2 ns225 0 ni2 0 0.0273708989476
Gb227_2 ns227 0 ni2 0 0.0258538802682
Gb229_2 ns229 0 ni2 0 0.0255135002088
Gb231_2 ns231 0 ni2 0 0.0246443426994
Gb233_2 ns233 0 ni2 0 0.0239803586638
Gb235_2 ns235 0 ni2 0 0.00594225926664
Gb237_2 ns237 0 ni2 0 0.00159871025886
Gb238_2 ns238 0 ni2 0 0.00545452372105
Gb240_2 ns240 0 ni2 0 5.57052778901e-05
Gb241_2 ns241 0 ni2 0 0.023242905775
Gb243_2 ns243 0 ni2 0 0.0231359419118
Gb245_2 ns245 0 ni2 0 0.0222300641188
Gb247_2 ns247 0 ni2 0 0.0209926044661
Gb249_2 ns249 0 ni2 0 0.0213858791233
Gb251_2 ns251 0 ni2 0 0.00776172738463
Gb253_2 ns253 0 ni2 0 0.00749438984893
Gb255_2 ns255 0 ni2 0 0.0202968420386
Gb257_2 ns257 0 ni2 0 0.0182932464234
Gb259_2 ns259 0 ni2 0 0.0110562719242
Gb261_2 ns261 0 ni2 0 0.0193612282785
Gb263_2 ns263 0 ni2 0 0.00949668782814
Gb265_2 ns265 0 ni2 0 0.0185489652236
Gb267_2 ns267 0 ni2 0 0.0178571719607
Gb269_2 ns269 0 ni2 0 0.0126353164129
Gb271_2 ns271 0 ni2 0 0.0111809823804
Gb273_2 ns273 0 ni2 0 0.016880045774
Gb275_2 ns275 0 ni2 0 0.0164676394267
Gb277_2 ns277 0 ni2 0 0.0159943770245
Gb279_2 ns279 0 ni2 0 0.0155239399215
Gb281_2 ns281 0 ni2 0 0.0145753583567
Gb283_2 ns283 0 ni2 0 0.0139298451821
Gb285_2 ns285 0 ni2 0 0.0151697486217
Gb287_2 ns287 0 ni2 0 0.0167240529377
Gb289_2 ns289 0 ni2 0 0.0129026364813
Gb291_2 ns291 0 ni2 0 0.0120036851736
Gb293_2 ns293 0 ni2 0 0.0119009754585
Gb295_2 ns295 0 ni2 0 0.0122378302889
Gb297_2 ns297 0 ni2 0 0.0126815386433
Gb299_2 ns299 0 ni2 0 0.0129010684786
Gb301_3 ns301 0 ni3 0 0.136306568658
Gb303_3 ns303 0 ni3 0 0.0723857132194
Gb305_3 ns305 0 ni3 0 0.0649975562917
Gb307_3 ns307 0 ni3 0 0.0626218067257
Gb309_3 ns309 0 ni3 0 0.0617049678443
Gb311_3 ns311 0 ni3 0 0.061063726364
Gb313_3 ns313 0 ni3 0 0.0596245935286
Gb315_3 ns315 0 ni3 0 0.0587637972445
Gb317_3 ns317 0 ni3 0 0.0571570559647
Gb319_3 ns319 0 ni3 0 0.0552099922543
Gb321_3 ns321 0 ni3 0 0.0544127437967
Gb323_3 ns323 0 ni3 0 0.0522606238162
Gb325_3 ns325 0 ni3 0 0.0518396577484
Gb327_3 ns327 0 ni3 0 0.0503658642661
Gb329_3 ns329 0 ni3 0 0.0481496588084
Gb331_3 ns331 0 ni3 0 0.0491577042979
Gb333_3 ns333 0 ni3 0 0.047304654079
Gb335_3 ns335 0 ni3 0 0.0454745881594
Gb337_3 ns337 0 ni3 0 0.0454196732002
Gb339_3 ns339 0 ni3 0 0.0435457648981
Gb341_3 ns341 0 ni3 0 0.0420807148302
Gb343_3 ns343 0 ni3 0 0.0421254067376
Gb345_3 ns345 0 ni3 0 0.0411665905414
Gb347_3 ns347 0 ni3 0 0.0395067173641
Gb349_3 ns349 0 ni3 0 0.0387733296286
Gb351_3 ns351 0 ni3 0 0.0376089956781
Gb353_3 ns353 0 ni3 0 0.0365326395939
Gb355_3 ns355 0 ni3 0 0.034643786111
Gb357_3 ns357 0 ni3 0 0.0349226326663
Gb359_3 ns359 0 ni3 0 0.0330341668694
Gb361_3 ns361 0 ni3 0 0.0328084054292
Gb363_3 ns363 0 ni3 0 0.0319236607971
Gb365_3 ns365 0 ni3 0 0.0308603346924
Gb367_3 ns367 0 ni3 0 0.0300890547365
Gb369_3 ns369 0 ni3 0 0.0293106559844
Gb371_3 ns371 0 ni3 0 0.0279720211501
Gb373_3 ns373 0 ni3 0 0.0271545964022
Gb375_3 ns375 0 ni3 0 0.0273708989476
Gb377_3 ns377 0 ni3 0 0.0258538802682
Gb379_3 ns379 0 ni3 0 0.0255135002088
Gb381_3 ns381 0 ni3 0 0.0246443426994
Gb383_3 ns383 0 ni3 0 0.0239803586638
Gb385_3 ns385 0 ni3 0 0.00594225926664
Gb387_3 ns387 0 ni3 0 0.00159871025886
Gb388_3 ns388 0 ni3 0 0.00545452372105
Gb390_3 ns390 0 ni3 0 5.57052778901e-05
Gb391_3 ns391 0 ni3 0 0.023242905775
Gb393_3 ns393 0 ni3 0 0.0231359419118
Gb395_3 ns395 0 ni3 0 0.0222300641188
Gb397_3 ns397 0 ni3 0 0.0209926044661
Gb399_3 ns399 0 ni3 0 0.0213858791233
Gb401_3 ns401 0 ni3 0 0.00776172738463
Gb403_3 ns403 0 ni3 0 0.00749438984893
Gb405_3 ns405 0 ni3 0 0.0202968420386
Gb407_3 ns407 0 ni3 0 0.0182932464234
Gb409_3 ns409 0 ni3 0 0.0110562719242
Gb411_3 ns411 0 ni3 0 0.0193612282785
Gb413_3 ns413 0 ni3 0 0.00949668782814
Gb415_3 ns415 0 ni3 0 0.0185489652236
Gb417_3 ns417 0 ni3 0 0.0178571719607
Gb419_3 ns419 0 ni3 0 0.0126353164129
Gb421_3 ns421 0 ni3 0 0.0111809823804
Gb423_3 ns423 0 ni3 0 0.016880045774
Gb425_3 ns425 0 ni3 0 0.0164676394267
Gb427_3 ns427 0 ni3 0 0.0159943770245
Gb429_3 ns429 0 ni3 0 0.0155239399215
Gb431_3 ns431 0 ni3 0 0.0145753583567
Gb433_3 ns433 0 ni3 0 0.0139298451821
Gb435_3 ns435 0 ni3 0 0.0151697486217
Gb437_3 ns437 0 ni3 0 0.0167240529377
Gb439_3 ns439 0 ni3 0 0.0129026364813
Gb441_3 ns441 0 ni3 0 0.0120036851736
Gb443_3 ns443 0 ni3 0 0.0119009754585
Gb445_3 ns445 0 ni3 0 0.0122378302889
Gb447_3 ns447 0 ni3 0 0.0126815386433
Gb449_3 ns449 0 ni3 0 0.0129010684786
Gb451_4 ns451 0 ni4 0 0.136306568658
Gb453_4 ns453 0 ni4 0 0.0723857132194
Gb455_4 ns455 0 ni4 0 0.0649975562917
Gb457_4 ns457 0 ni4 0 0.0626218067257
Gb459_4 ns459 0 ni4 0 0.0617049678443
Gb461_4 ns461 0 ni4 0 0.061063726364
Gb463_4 ns463 0 ni4 0 0.0596245935286
Gb465_4 ns465 0 ni4 0 0.0587637972445
Gb467_4 ns467 0 ni4 0 0.0571570559647
Gb469_4 ns469 0 ni4 0 0.0552099922543
Gb471_4 ns471 0 ni4 0 0.0544127437967
Gb473_4 ns473 0 ni4 0 0.0522606238162
Gb475_4 ns475 0 ni4 0 0.0518396577484
Gb477_4 ns477 0 ni4 0 0.0503658642661
Gb479_4 ns479 0 ni4 0 0.0481496588084
Gb481_4 ns481 0 ni4 0 0.0491577042979
Gb483_4 ns483 0 ni4 0 0.047304654079
Gb485_4 ns485 0 ni4 0 0.0454745881594
Gb487_4 ns487 0 ni4 0 0.0454196732002
Gb489_4 ns489 0 ni4 0 0.0435457648981
Gb491_4 ns491 0 ni4 0 0.0420807148302
Gb493_4 ns493 0 ni4 0 0.0421254067376
Gb495_4 ns495 0 ni4 0 0.0411665905414
Gb497_4 ns497 0 ni4 0 0.0395067173641
Gb499_4 ns499 0 ni4 0 0.0387733296286
Gb501_4 ns501 0 ni4 0 0.0376089956781
Gb503_4 ns503 0 ni4 0 0.0365326395939
Gb505_4 ns505 0 ni4 0 0.034643786111
Gb507_4 ns507 0 ni4 0 0.0349226326663
Gb509_4 ns509 0 ni4 0 0.0330341668694
Gb511_4 ns511 0 ni4 0 0.0328084054292
Gb513_4 ns513 0 ni4 0 0.0319236607971
Gb515_4 ns515 0 ni4 0 0.0308603346924
Gb517_4 ns517 0 ni4 0 0.0300890547365
Gb519_4 ns519 0 ni4 0 0.0293106559844
Gb521_4 ns521 0 ni4 0 0.0279720211501
Gb523_4 ns523 0 ni4 0 0.0271545964022
Gb525_4 ns525 0 ni4 0 0.0273708989476
Gb527_4 ns527 0 ni4 0 0.0258538802682
Gb529_4 ns529 0 ni4 0 0.0255135002088
Gb531_4 ns531 0 ni4 0 0.0246443426994
Gb533_4 ns533 0 ni4 0 0.0239803586638
Gb535_4 ns535 0 ni4 0 0.00594225926664
Gb537_4 ns537 0 ni4 0 0.00159871025886
Gb538_4 ns538 0 ni4 0 0.00545452372105
Gb540_4 ns540 0 ni4 0 5.57052778901e-05
Gb541_4 ns541 0 ni4 0 0.023242905775
Gb543_4 ns543 0 ni4 0 0.0231359419118
Gb545_4 ns545 0 ni4 0 0.0222300641188
Gb547_4 ns547 0 ni4 0 0.0209926044661
Gb549_4 ns549 0 ni4 0 0.0213858791233
Gb551_4 ns551 0 ni4 0 0.00776172738463
Gb553_4 ns553 0 ni4 0 0.00749438984893
Gb555_4 ns555 0 ni4 0 0.0202968420386
Gb557_4 ns557 0 ni4 0 0.0182932464234
Gb559_4 ns559 0 ni4 0 0.0110562719242
Gb561_4 ns561 0 ni4 0 0.0193612282785
Gb563_4 ns563 0 ni4 0 0.00949668782814
Gb565_4 ns565 0 ni4 0 0.0185489652236
Gb567_4 ns567 0 ni4 0 0.0178571719607
Gb569_4 ns569 0 ni4 0 0.0126353164129
Gb571_4 ns571 0 ni4 0 0.0111809823804
Gb573_4 ns573 0 ni4 0 0.016880045774
Gb575_4 ns575 0 ni4 0 0.0164676394267
Gb577_4 ns577 0 ni4 0 0.0159943770245
Gb579_4 ns579 0 ni4 0 0.0155239399215
Gb581_4 ns581 0 ni4 0 0.0145753583567
Gb583_4 ns583 0 ni4 0 0.0139298451821
Gb585_4 ns585 0 ni4 0 0.0151697486217
Gb587_4 ns587 0 ni4 0 0.0167240529377
Gb589_4 ns589 0 ni4 0 0.0129026364813
Gb591_4 ns591 0 ni4 0 0.0120036851736
Gb593_4 ns593 0 ni4 0 0.0119009754585
Gb595_4 ns595 0 ni4 0 0.0122378302889
Gb597_4 ns597 0 ni4 0 0.0126815386433
Gb599_4 ns599 0 ni4 0 0.0129010684786
Gb601_5 ns601 0 ni5 0 0.136306568658
Gb603_5 ns603 0 ni5 0 0.0723857132194
Gb605_5 ns605 0 ni5 0 0.0649975562917
Gb607_5 ns607 0 ni5 0 0.0626218067257
Gb609_5 ns609 0 ni5 0 0.0617049678443
Gb611_5 ns611 0 ni5 0 0.061063726364
Gb613_5 ns613 0 ni5 0 0.0596245935286
Gb615_5 ns615 0 ni5 0 0.0587637972445
Gb617_5 ns617 0 ni5 0 0.0571570559647
Gb619_5 ns619 0 ni5 0 0.0552099922543
Gb621_5 ns621 0 ni5 0 0.0544127437967
Gb623_5 ns623 0 ni5 0 0.0522606238162
Gb625_5 ns625 0 ni5 0 0.0518396577484
Gb627_5 ns627 0 ni5 0 0.0503658642661
Gb629_5 ns629 0 ni5 0 0.0481496588084
Gb631_5 ns631 0 ni5 0 0.0491577042979
Gb633_5 ns633 0 ni5 0 0.047304654079
Gb635_5 ns635 0 ni5 0 0.0454745881594
Gb637_5 ns637 0 ni5 0 0.0454196732002
Gb639_5 ns639 0 ni5 0 0.0435457648981
Gb641_5 ns641 0 ni5 0 0.0420807148302
Gb643_5 ns643 0 ni5 0 0.0421254067376
Gb645_5 ns645 0 ni5 0 0.0411665905414
Gb647_5 ns647 0 ni5 0 0.0395067173641
Gb649_5 ns649 0 ni5 0 0.0387733296286
Gb651_5 ns651 0 ni5 0 0.0376089956781
Gb653_5 ns653 0 ni5 0 0.0365326395939
Gb655_5 ns655 0 ni5 0 0.034643786111
Gb657_5 ns657 0 ni5 0 0.0349226326663
Gb659_5 ns659 0 ni5 0 0.0330341668694
Gb661_5 ns661 0 ni5 0 0.0328084054292
Gb663_5 ns663 0 ni5 0 0.0319236607971
Gb665_5 ns665 0 ni5 0 0.0308603346924
Gb667_5 ns667 0 ni5 0 0.0300890547365
Gb669_5 ns669 0 ni5 0 0.0293106559844
Gb671_5 ns671 0 ni5 0 0.0279720211501
Gb673_5 ns673 0 ni5 0 0.0271545964022
Gb675_5 ns675 0 ni5 0 0.0273708989476
Gb677_5 ns677 0 ni5 0 0.0258538802682
Gb679_5 ns679 0 ni5 0 0.0255135002088
Gb681_5 ns681 0 ni5 0 0.0246443426994
Gb683_5 ns683 0 ni5 0 0.0239803586638
Gb685_5 ns685 0 ni5 0 0.00594225926664
Gb687_5 ns687 0 ni5 0 0.00159871025886
Gb688_5 ns688 0 ni5 0 0.00545452372105
Gb690_5 ns690 0 ni5 0 5.57052778901e-05
Gb691_5 ns691 0 ni5 0 0.023242905775
Gb693_5 ns693 0 ni5 0 0.0231359419118
Gb695_5 ns695 0 ni5 0 0.0222300641188
Gb697_5 ns697 0 ni5 0 0.0209926044661
Gb699_5 ns699 0 ni5 0 0.0213858791233
Gb701_5 ns701 0 ni5 0 0.00776172738463
Gb703_5 ns703 0 ni5 0 0.00749438984893
Gb705_5 ns705 0 ni5 0 0.0202968420386
Gb707_5 ns707 0 ni5 0 0.0182932464234
Gb709_5 ns709 0 ni5 0 0.0110562719242
Gb711_5 ns711 0 ni5 0 0.0193612282785
Gb713_5 ns713 0 ni5 0 0.00949668782814
Gb715_5 ns715 0 ni5 0 0.0185489652236
Gb717_5 ns717 0 ni5 0 0.0178571719607
Gb719_5 ns719 0 ni5 0 0.0126353164129
Gb721_5 ns721 0 ni5 0 0.0111809823804
Gb723_5 ns723 0 ni5 0 0.016880045774
Gb725_5 ns725 0 ni5 0 0.0164676394267
Gb727_5 ns727 0 ni5 0 0.0159943770245
Gb729_5 ns729 0 ni5 0 0.0155239399215
Gb731_5 ns731 0 ni5 0 0.0145753583567
Gb733_5 ns733 0 ni5 0 0.0139298451821
Gb735_5 ns735 0 ni5 0 0.0151697486217
Gb737_5 ns737 0 ni5 0 0.0167240529377
Gb739_5 ns739 0 ni5 0 0.0129026364813
Gb741_5 ns741 0 ni5 0 0.0120036851736
Gb743_5 ns743 0 ni5 0 0.0119009754585
Gb745_5 ns745 0 ni5 0 0.0122378302889
Gb747_5 ns747 0 ni5 0 0.0126815386433
Gb749_5 ns749 0 ni5 0 0.0129010684786
Gb751_6 ns751 0 ni6 0 0.136306568658
Gb753_6 ns753 0 ni6 0 0.0723857132194
Gb755_6 ns755 0 ni6 0 0.0649975562917
Gb757_6 ns757 0 ni6 0 0.0626218067257
Gb759_6 ns759 0 ni6 0 0.0617049678443
Gb761_6 ns761 0 ni6 0 0.061063726364
Gb763_6 ns763 0 ni6 0 0.0596245935286
Gb765_6 ns765 0 ni6 0 0.0587637972445
Gb767_6 ns767 0 ni6 0 0.0571570559647
Gb769_6 ns769 0 ni6 0 0.0552099922543
Gb771_6 ns771 0 ni6 0 0.0544127437967
Gb773_6 ns773 0 ni6 0 0.0522606238162
Gb775_6 ns775 0 ni6 0 0.0518396577484
Gb777_6 ns777 0 ni6 0 0.0503658642661
Gb779_6 ns779 0 ni6 0 0.0481496588084
Gb781_6 ns781 0 ni6 0 0.0491577042979
Gb783_6 ns783 0 ni6 0 0.047304654079
Gb785_6 ns785 0 ni6 0 0.0454745881594
Gb787_6 ns787 0 ni6 0 0.0454196732002
Gb789_6 ns789 0 ni6 0 0.0435457648981
Gb791_6 ns791 0 ni6 0 0.0420807148302
Gb793_6 ns793 0 ni6 0 0.0421254067376
Gb795_6 ns795 0 ni6 0 0.0411665905414
Gb797_6 ns797 0 ni6 0 0.0395067173641
Gb799_6 ns799 0 ni6 0 0.0387733296286
Gb801_6 ns801 0 ni6 0 0.0376089956781
Gb803_6 ns803 0 ni6 0 0.0365326395939
Gb805_6 ns805 0 ni6 0 0.034643786111
Gb807_6 ns807 0 ni6 0 0.0349226326663
Gb809_6 ns809 0 ni6 0 0.0330341668694
Gb811_6 ns811 0 ni6 0 0.0328084054292
Gb813_6 ns813 0 ni6 0 0.0319236607971
Gb815_6 ns815 0 ni6 0 0.0308603346924
Gb817_6 ns817 0 ni6 0 0.0300890547365
Gb819_6 ns819 0 ni6 0 0.0293106559844
Gb821_6 ns821 0 ni6 0 0.0279720211501
Gb823_6 ns823 0 ni6 0 0.0271545964022
Gb825_6 ns825 0 ni6 0 0.0273708989476
Gb827_6 ns827 0 ni6 0 0.0258538802682
Gb829_6 ns829 0 ni6 0 0.0255135002088
Gb831_6 ns831 0 ni6 0 0.0246443426994
Gb833_6 ns833 0 ni6 0 0.0239803586638
Gb835_6 ns835 0 ni6 0 0.00594225926664
Gb837_6 ns837 0 ni6 0 0.00159871025886
Gb838_6 ns838 0 ni6 0 0.00545452372105
Gb840_6 ns840 0 ni6 0 5.57052778901e-05
Gb841_6 ns841 0 ni6 0 0.023242905775
Gb843_6 ns843 0 ni6 0 0.0231359419118
Gb845_6 ns845 0 ni6 0 0.0222300641188
Gb847_6 ns847 0 ni6 0 0.0209926044661
Gb849_6 ns849 0 ni6 0 0.0213858791233
Gb851_6 ns851 0 ni6 0 0.00776172738463
Gb853_6 ns853 0 ni6 0 0.00749438984893
Gb855_6 ns855 0 ni6 0 0.0202968420386
Gb857_6 ns857 0 ni6 0 0.0182932464234
Gb859_6 ns859 0 ni6 0 0.0110562719242
Gb861_6 ns861 0 ni6 0 0.0193612282785
Gb863_6 ns863 0 ni6 0 0.00949668782814
Gb865_6 ns865 0 ni6 0 0.0185489652236
Gb867_6 ns867 0 ni6 0 0.0178571719607
Gb869_6 ns869 0 ni6 0 0.0126353164129
Gb871_6 ns871 0 ni6 0 0.0111809823804
Gb873_6 ns873 0 ni6 0 0.016880045774
Gb875_6 ns875 0 ni6 0 0.0164676394267
Gb877_6 ns877 0 ni6 0 0.0159943770245
Gb879_6 ns879 0 ni6 0 0.0155239399215
Gb881_6 ns881 0 ni6 0 0.0145753583567
Gb883_6 ns883 0 ni6 0 0.0139298451821
Gb885_6 ns885 0 ni6 0 0.0151697486217
Gb887_6 ns887 0 ni6 0 0.0167240529377
Gb889_6 ns889 0 ni6 0 0.0129026364813
Gb891_6 ns891 0 ni6 0 0.0120036851736
Gb893_6 ns893 0 ni6 0 0.0119009754585
Gb895_6 ns895 0 ni6 0 0.0122378302889
Gb897_6 ns897 0 ni6 0 0.0126815386433
Gb899_6 ns899 0 ni6 0 0.0129010684786

Gc1_1 0 n2 ns1 0 -0.00569951773549
Gc1_2 0 n2 ns2 0 0.00263376639926
Gc1_3 0 n2 ns3 0 -0.000402263937259
Gc1_4 0 n2 ns4 0 -4.46449408762e-05
Gc1_5 0 n2 ns5 0 -4.30427831123e-05
Gc1_6 0 n2 ns6 0 3.46823498661e-05
Gc1_7 0 n2 ns7 0 0.000152908780757
Gc1_8 0 n2 ns8 0 -0.000163594516859
Gc1_9 0 n2 ns9 0 7.98935815911e-08
Gc1_10 0 n2 ns10 0 -1.06601870559e-07
Gc1_11 0 n2 ns11 0 -1.674109021e-05
Gc1_12 0 n2 ns12 0 0.000125050886868
Gc1_13 0 n2 ns13 0 -4.64776053099e-05
Gc1_14 0 n2 ns14 0 -4.98290073963e-05
Gc1_15 0 n2 ns15 0 -3.62011324361e-05
Gc1_16 0 n2 ns16 0 -0.000188958567409
Gc1_17 0 n2 ns17 0 0.000165329725327
Gc1_18 0 n2 ns18 0 0.000100333442764
Gc1_19 0 n2 ns19 0 -0.000267089650097
Gc1_20 0 n2 ns20 0 -8.23473936518e-05
Gc1_21 0 n2 ns21 0 4.34716475599e-05
Gc1_22 0 n2 ns22 0 -0.000162838036388
Gc1_23 0 n2 ns23 0 5.21585579594e-05
Gc1_24 0 n2 ns24 0 0.000257189259664
Gc1_25 0 n2 ns25 0 1.13275059423e-05
Gc1_26 0 n2 ns26 0 4.89087519953e-06
Gc1_27 0 n2 ns27 0 -9.02120459886e-06
Gc1_28 0 n2 ns28 0 -0.00020538209718
Gc1_29 0 n2 ns29 0 7.36408634198e-05
Gc1_30 0 n2 ns30 0 -0.000188340780751
Gc1_31 0 n2 ns31 0 3.03083901862e-06
Gc1_32 0 n2 ns32 0 -1.39972161769e-06
Gc1_33 0 n2 ns33 0 -1.07102403368e-05
Gc1_34 0 n2 ns34 0 -2.122534023e-06
Gc1_35 0 n2 ns35 0 -0.000188901544315
Gc1_36 0 n2 ns36 0 -0.000254165415312
Gc1_37 0 n2 ns37 0 4.17459036527e-05
Gc1_38 0 n2 ns38 0 1.04079301265e-05
Gc1_39 0 n2 ns39 0 -0.000130703195238
Gc1_40 0 n2 ns40 0 5.08752338652e-05
Gc1_41 0 n2 ns41 0 0.000344228468834
Gc1_42 0 n2 ns42 0 -0.000363596218333
Gc1_43 0 n2 ns43 0 -2.51418945767e-05
Gc1_44 0 n2 ns44 0 4.37096731596e-05
Gc1_45 0 n2 ns45 0 -1.53120178885e-05
Gc1_46 0 n2 ns46 0 -4.15113172616e-05
Gc1_47 0 n2 ns47 0 -0.000320345489154
Gc1_48 0 n2 ns48 0 -0.00036762274364
Gc1_49 0 n2 ns49 0 -8.93272007438e-05
Gc1_50 0 n2 ns50 0 2.39401863266e-05
Gc1_51 0 n2 ns51 0 -8.13271440598e-05
Gc1_52 0 n2 ns52 0 -8.39439287037e-05
Gc1_53 0 n2 ns53 0 -0.000194254163923
Gc1_54 0 n2 ns54 0 2.84475818334e-05
Gc1_55 0 n2 ns55 0 -0.000379285241517
Gc1_56 0 n2 ns56 0 0.000161906116694
Gc1_57 0 n2 ns57 0 7.10847216132e-05
Gc1_58 0 n2 ns58 0 -7.98787550624e-05
Gc1_59 0 n2 ns59 0 -3.35316113834e-05
Gc1_60 0 n2 ns60 0 -2.32456679295e-05
Gc1_61 0 n2 ns61 0 3.23639209078e-05
Gc1_62 0 n2 ns62 0 0.000168689190083
Gc1_63 0 n2 ns63 0 0.000315462899782
Gc1_64 0 n2 ns64 0 -0.000530932571561
Gc1_65 0 n2 ns65 0 8.06019774556e-06
Gc1_66 0 n2 ns66 0 1.4421446732e-06
Gc1_67 0 n2 ns67 0 4.0011705442e-05
Gc1_68 0 n2 ns68 0 -9.60850790836e-05
Gc1_69 0 n2 ns69 0 5.22099540561e-07
Gc1_70 0 n2 ns70 0 1.3518992935e-07
Gc1_71 0 n2 ns71 0 5.40284272771e-05
Gc1_72 0 n2 ns72 0 -0.000940004888755
Gc1_73 0 n2 ns73 0 -0.00045035860705
Gc1_74 0 n2 ns74 0 -0.000256250074049
Gc1_75 0 n2 ns75 0 1.56381772742e-05
Gc1_76 0 n2 ns76 0 -4.93773492949e-06
Gc1_77 0 n2 ns77 0 1.2087227807e-05
Gc1_78 0 n2 ns78 0 -5.52990556038e-05
Gc1_79 0 n2 ns79 0 -7.37356882347e-06
Gc1_80 0 n2 ns80 0 -7.97087237376e-05
Gc1_81 0 n2 ns81 0 -0.00170381757679
Gc1_82 0 n2 ns82 0 -0.000314381049591
Gc1_83 0 n2 ns83 0 -1.5969042091e-05
Gc1_84 0 n2 ns84 0 4.54303778517e-05
Gc1_85 0 n2 ns85 0 -0.0187600843094
Gc1_86 0 n2 ns86 0 0.00908862714586
Gc1_87 0 n2 ns87 0 0.00744503225695
Gc1_88 0 n2 ns88 0 0.0107090122155
Gc1_89 0 n2 ns89 0 -0.0117660120154
Gc1_90 0 n2 ns90 0 9.88788688154e-05
Gc1_91 0 n2 ns91 0 -2.70595668246e-05
Gc1_92 0 n2 ns92 0 -1.34953492615e-05
Gc1_93 0 n2 ns93 0 -1.81767098781e-07
Gc1_94 0 n2 ns94 0 1.92171570724e-07
Gc1_95 0 n2 ns95 0 -7.12027727987e-06
Gc1_96 0 n2 ns96 0 -4.14151975909e-06
Gc1_97 0 n2 ns97 0 -0.000209235842931
Gc1_98 0 n2 ns98 0 -0.000776012199117
Gc1_99 0 n2 ns99 0 -3.63295278517e-07
Gc1_100 0 n2 ns100 0 1.44072377864e-06
Gc1_101 0 n2 ns101 0 0.000610648080762
Gc1_102 0 n2 ns102 0 0.00151972498851
Gc1_103 0 n2 ns103 0 8.41747648345e-06
Gc1_104 0 n2 ns104 0 -2.15892482443e-05
Gc1_105 0 n2 ns105 0 -0.000203227582979
Gc1_106 0 n2 ns106 0 0.00020790212435
Gc1_107 0 n2 ns107 0 -0.0024736806061
Gc1_108 0 n2 ns108 0 0.00115009884664
Gc1_109 0 n2 ns109 0 -0.0022245249685
Gc1_110 0 n2 ns110 0 0.000764738715102
Gc1_111 0 n2 ns111 0 -6.96960760088e-05
Gc1_112 0 n2 ns112 0 -4.37365705386e-05
Gc1_113 0 n2 ns113 0 1.64493372648e-06
Gc1_114 0 n2 ns114 0 -1.06288902415e-05
Gc1_115 0 n2 ns115 0 -2.7926854163e-05
Gc1_116 0 n2 ns116 0 -5.32392679072e-05
Gc1_117 0 n2 ns117 0 0.000131479899074
Gc1_118 0 n2 ns118 0 -0.000142376208346
Gc1_119 0 n2 ns119 0 -0.000679479805638
Gc1_120 0 n2 ns120 0 -0.000615636899936
Gc1_121 0 n2 ns121 0 -1.62610605651e-05
Gc1_122 0 n2 ns122 0 6.7218276274e-05
Gc1_123 0 n2 ns123 0 3.11561844885e-05
Gc1_124 0 n2 ns124 0 -1.49903440915e-05
Gc1_125 0 n2 ns125 0 1.24514635041e-05
Gc1_126 0 n2 ns126 0 1.64840512807e-05
Gc1_127 0 n2 ns127 0 9.20684987801e-06
Gc1_128 0 n2 ns128 0 1.85651060904e-05
Gc1_129 0 n2 ns129 0 3.10606305256e-05
Gc1_130 0 n2 ns130 0 7.63778940376e-06
Gc1_131 0 n2 ns131 0 1.97081934704e-05
Gc1_132 0 n2 ns132 0 -3.59183847785e-05
Gc1_133 0 n2 ns133 0 1.10702802156e-05
Gc1_134 0 n2 ns134 0 -9.20177997629e-06
Gc1_135 0 n2 ns135 0 -2.2715427657e-05
Gc1_136 0 n2 ns136 0 2.69131567099e-05
Gc1_137 0 n2 ns137 0 -1.78452154936e-07
Gc1_138 0 n2 ns138 0 -1.07993779876e-06
Gc1_139 0 n2 ns139 0 2.60153156386e-05
Gc1_140 0 n2 ns140 0 -2.34155889677e-06
Gc1_141 0 n2 ns141 0 1.37058839189e-06
Gc1_142 0 n2 ns142 0 -5.37345626272e-07
Gc1_143 0 n2 ns143 0 -1.24288163595e-08
Gc1_144 0 n2 ns144 0 1.03278465913e-07
Gc1_145 0 n2 ns145 0 1.11941711511e-06
Gc1_146 0 n2 ns146 0 1.43173935895e-06
Gc1_147 0 n2 ns147 0 -4.30382863541e-08
Gc1_148 0 n2 ns148 0 -3.77088187817e-06
Gc1_149 0 n2 ns149 0 -1.37645439554e-07
Gc1_150 0 n2 ns150 0 -1.80978628905e-06
Gc1_151 0 n2 ns151 0 -0.00046890018424
Gc1_152 0 n2 ns152 0 0.00343934035392
Gc1_153 0 n2 ns153 0 -0.000301458583839
Gc1_154 0 n2 ns154 0 -3.70146639628e-05
Gc1_155 0 n2 ns155 0 0.000132374356849
Gc1_156 0 n2 ns156 0 -0.000194549750403
Gc1_157 0 n2 ns157 0 -4.58688528476e-05
Gc1_158 0 n2 ns158 0 5.77728980996e-05
Gc1_159 0 n2 ns159 0 5.54215759119e-09
Gc1_160 0 n2 ns160 0 -9.20228941406e-10
Gc1_161 0 n2 ns161 0 -0.000152843346068
Gc1_162 0 n2 ns162 0 9.80150760254e-05
Gc1_163 0 n2 ns163 0 7.97881605096e-06
Gc1_164 0 n2 ns164 0 2.75001209273e-05
Gc1_165 0 n2 ns165 0 -2.46546135356e-05
Gc1_166 0 n2 ns166 0 -8.61231274068e-05
Gc1_167 0 n2 ns167 0 -1.80797738376e-06
Gc1_168 0 n2 ns168 0 -0.000171914396581
Gc1_169 0 n2 ns169 0 9.99371496646e-05
Gc1_170 0 n2 ns170 0 -6.65707020648e-05
Gc1_171 0 n2 ns171 0 2.88329691053e-05
Gc1_172 0 n2 ns172 0 -1.82495393923e-05
Gc1_173 0 n2 ns173 0 -0.000583879514452
Gc1_174 0 n2 ns174 0 0.000100760458782
Gc1_175 0 n2 ns175 0 1.66385220511e-05
Gc1_176 0 n2 ns176 0 1.57532805743e-05
Gc1_177 0 n2 ns177 0 -2.92801656018e-05
Gc1_178 0 n2 ns178 0 -1.34421531956e-05
Gc1_179 0 n2 ns179 0 -0.000148531187279
Gc1_180 0 n2 ns180 0 -0.000446879554654
Gc1_181 0 n2 ns181 0 8.72061566155e-07
Gc1_182 0 n2 ns182 0 -4.09291007505e-06
Gc1_183 0 n2 ns183 0 -3.63087920438e-06
Gc1_184 0 n2 ns184 0 2.73105507808e-07
Gc1_185 0 n2 ns185 0 -0.000304204355425
Gc1_186 0 n2 ns186 0 0.000230565522458
Gc1_187 0 n2 ns187 0 2.31746071722e-05
Gc1_188 0 n2 ns188 0 -2.29067205759e-05
Gc1_189 0 n2 ns189 0 -5.79444993616e-05
Gc1_190 0 n2 ns190 0 2.75471106644e-05
Gc1_191 0 n2 ns191 0 -0.00115183994658
Gc1_192 0 n2 ns192 0 0.000239543133491
Gc1_193 0 n2 ns193 0 1.93182285416e-05
Gc1_194 0 n2 ns194 0 -7.04391757931e-06
Gc1_195 0 n2 ns195 0 -7.6383898676e-08
Gc1_196 0 n2 ns196 0 5.9246679813e-06
Gc1_197 0 n2 ns197 0 -0.000104831140452
Gc1_198 0 n2 ns198 0 4.16273985992e-05
Gc1_199 0 n2 ns199 0 5.07308502296e-06
Gc1_200 0 n2 ns200 0 7.21651389041e-05
Gc1_201 0 n2 ns201 0 -5.08111681667e-05
Gc1_202 0 n2 ns202 0 0.000158623139319
Gc1_203 0 n2 ns203 0 -3.9351017986e-05
Gc1_204 0 n2 ns204 0 0.000308553075752
Gc1_205 0 n2 ns205 0 -0.000430068908404
Gc1_206 0 n2 ns206 0 0.000651400175435
Gc1_207 0 n2 ns207 0 -5.38010986186e-05
Gc1_208 0 n2 ns208 0 -4.02905187599e-05
Gc1_209 0 n2 ns209 0 5.18544378407e-05
Gc1_210 0 n2 ns210 0 -2.62176478346e-05
Gc1_211 0 n2 ns211 0 -0.000231552168807
Gc1_212 0 n2 ns212 0 -0.000140960097516
Gc1_213 0 n2 ns213 0 -0.000879438783951
Gc1_214 0 n2 ns214 0 0.000280748076432
Gc1_215 0 n2 ns215 0 -2.83255733104e-06
Gc1_216 0 n2 ns216 0 6.92713704259e-06
Gc1_217 0 n2 ns217 0 6.19710623629e-05
Gc1_218 0 n2 ns218 0 -1.30948073611e-05
Gc1_219 0 n2 ns219 0 7.54075442011e-07
Gc1_220 0 n2 ns220 0 5.18445043153e-07
Gc1_221 0 n2 ns221 0 -0.000931160344085
Gc1_222 0 n2 ns222 0 0.000270047166525
Gc1_223 0 n2 ns223 0 -9.82171942555e-06
Gc1_224 0 n2 ns224 0 0.000959901048991
Gc1_225 0 n2 ns225 0 -9.73154396693e-06
Gc1_226 0 n2 ns226 0 -3.06568552759e-06
Gc1_227 0 n2 ns227 0 -0.000201963403466
Gc1_228 0 n2 ns228 0 -8.43078638946e-05
Gc1_229 0 n2 ns229 0 -0.00021085287996
Gc1_230 0 n2 ns230 0 0.000259203974467
Gc1_231 0 n2 ns231 0 -0.00204024402193
Gc1_232 0 n2 ns232 0 0.00255083430343
Gc1_233 0 n2 ns233 0 4.40537365354e-05
Gc1_234 0 n2 ns234 0 -1.59035013439e-05
Gc1_235 0 n2 ns235 0 0.0437523350841
Gc1_236 0 n2 ns236 0 0.014789757091
Gc1_237 0 n2 ns237 0 -0.0101923897485
Gc1_238 0 n2 ns238 0 0.0116913823011
Gc1_239 0 n2 ns239 0 0.00961470037709
Gc1_240 0 n2 ns240 0 -0.000131794471341
Gc1_241 0 n2 ns241 0 2.48162894697e-05
Gc1_242 0 n2 ns242 0 1.24978560965e-05
Gc1_243 0 n2 ns243 0 2.78646899351e-07
Gc1_244 0 n2 ns244 0 3.35199466859e-07
Gc1_245 0 n2 ns245 0 5.71822056779e-06
Gc1_246 0 n2 ns246 0 6.25908100572e-06
Gc1_247 0 n2 ns247 0 0.000464728470745
Gc1_248 0 n2 ns248 0 0.000258625394722
Gc1_249 0 n2 ns249 0 -9.90722782419e-07
Gc1_250 0 n2 ns250 0 -2.69904951431e-07
Gc1_251 0 n2 ns251 0 -0.00318456000778
Gc1_252 0 n2 ns252 0 -0.000881836350612
Gc1_253 0 n2 ns253 0 4.77698038548e-05
Gc1_254 0 n2 ns254 0 -4.94319762065e-06
Gc1_255 0 n2 ns255 0 -0.000128309424805
Gc1_256 0 n2 ns256 0 0.000117272324177
Gc1_257 0 n2 ns257 0 -0.000894061412816
Gc1_258 0 n2 ns258 0 0.0109896050569
Gc1_259 0 n2 ns259 0 0.00975447880562
Gc1_260 0 n2 ns260 0 0.0169386323792
Gc1_261 0 n2 ns261 0 -3.79118176057e-05
Gc1_262 0 n2 ns262 0 7.40512306581e-05
Gc1_263 0 n2 ns263 0 5.41293783656e-06
Gc1_264 0 n2 ns264 0 -7.80377057317e-06
Gc1_265 0 n2 ns265 0 -2.21380631609e-05
Gc1_266 0 n2 ns266 0 -7.97823990121e-05
Gc1_267 0 n2 ns267 0 -0.00011887592727
Gc1_268 0 n2 ns268 0 -0.000330695601048
Gc1_269 0 n2 ns269 0 0.00226985288043
Gc1_270 0 n2 ns270 0 0.00202003309376
Gc1_271 0 n2 ns271 0 -1.63742331845e-06
Gc1_272 0 n2 ns272 0 1.54149939148e-05
Gc1_273 0 n2 ns273 0 1.56668497145e-05
Gc1_274 0 n2 ns274 0 -1.23645890197e-05
Gc1_275 0 n2 ns275 0 2.00997985223e-05
Gc1_276 0 n2 ns276 0 -9.49201881723e-06
Gc1_277 0 n2 ns277 0 -2.556786887e-06
Gc1_278 0 n2 ns278 0 -5.59732563552e-06
Gc1_279 0 n2 ns279 0 -6.82654990875e-06
Gc1_280 0 n2 ns280 0 -1.92957143921e-05
Gc1_281 0 n2 ns281 0 -6.40283311204e-05
Gc1_282 0 n2 ns282 0 -1.54704392827e-05
Gc1_283 0 n2 ns283 0 5.37999628997e-06
Gc1_284 0 n2 ns284 0 2.58198848984e-06
Gc1_285 0 n2 ns285 0 1.79683276679e-05
Gc1_286 0 n2 ns286 0 -1.56321189542e-06
Gc1_287 0 n2 ns287 0 6.46228253287e-07
Gc1_288 0 n2 ns288 0 -2.02356906621e-07
Gc1_289 0 n2 ns289 0 2.40834498957e-06
Gc1_290 0 n2 ns290 0 -1.86224179468e-05
Gc1_291 0 n2 ns291 0 -4.83661405604e-07
Gc1_292 0 n2 ns292 0 -8.93385905648e-06
Gc1_293 0 n2 ns293 0 -1.23474276885e-06
Gc1_294 0 n2 ns294 0 -2.02729417386e-06
Gc1_295 0 n2 ns295 0 2.64704754709e-06
Gc1_296 0 n2 ns296 0 -5.86795088487e-06
Gc1_297 0 n2 ns297 0 -5.54253227157e-06
Gc1_298 0 n2 ns298 0 1.63053975038e-06
Gc1_299 0 n2 ns299 0 -3.09051398814e-06
Gc1_300 0 n2 ns300 0 1.53465869593e-06
Gc1_301 0 n2 ns301 0 0.000996352839775
Gc1_302 0 n2 ns302 0 -0.00169052773173
Gc1_303 0 n2 ns303 0 0.000589015291072
Gc1_304 0 n2 ns304 0 8.70603361974e-06
Gc1_305 0 n2 ns305 0 -6.45587567334e-05
Gc1_306 0 n2 ns306 0 4.16577641967e-05
Gc1_307 0 n2 ns307 0 9.32203147209e-05
Gc1_308 0 n2 ns308 0 -7.5666347253e-06
Gc1_309 0 n2 ns309 0 -8.85110962737e-09
Gc1_310 0 n2 ns310 0 7.71233547654e-08
Gc1_311 0 n2 ns311 0 1.5832338993e-05
Gc1_312 0 n2 ns312 0 6.98736270824e-05
Gc1_313 0 n2 ns313 0 2.80398292895e-05
Gc1_314 0 n2 ns314 0 -6.46805293938e-06
Gc1_315 0 n2 ns315 0 5.97576671634e-05
Gc1_316 0 n2 ns316 0 -0.000105289865625
Gc1_317 0 n2 ns317 0 3.41195398413e-05
Gc1_318 0 n2 ns318 0 9.24808807983e-05
Gc1_319 0 n2 ns319 0 -3.81723221127e-05
Gc1_320 0 n2 ns320 0 2.08147916217e-05
Gc1_321 0 n2 ns321 0 0.000138753011704
Gc1_322 0 n2 ns322 0 -0.00014920862549
Gc1_323 0 n2 ns323 0 7.86669648797e-05
Gc1_324 0 n2 ns324 0 0.000179570357724
Gc1_325 0 n2 ns325 0 1.14912379545e-06
Gc1_326 0 n2 ns326 0 -8.49012808765e-07
Gc1_327 0 n2 ns327 0 0.00014595007703
Gc1_328 0 n2 ns328 0 -0.000136764699622
Gc1_329 0 n2 ns329 0 0.000300356275976
Gc1_330 0 n2 ns330 0 -0.000234780380318
Gc1_331 0 n2 ns331 0 3.9507946325e-06
Gc1_332 0 n2 ns332 0 1.03337295507e-07
Gc1_333 0 n2 ns333 0 -6.3058128783e-06
Gc1_334 0 n2 ns334 0 -6.17579391416e-06
Gc1_335 0 n2 ns335 0 -8.63589608619e-05
Gc1_336 0 n2 ns336 0 -0.000459188201823
Gc1_337 0 n2 ns337 0 3.9551355911e-05
Gc1_338 0 n2 ns338 0 3.04070263479e-05
Gc1_339 0 n2 ns339 0 -0.00011132195689
Gc1_340 0 n2 ns340 0 1.75973309496e-05
Gc1_341 0 n2 ns341 0 0.000177006018275
Gc1_342 0 n2 ns342 0 -0.000254688416919
Gc1_343 0 n2 ns343 0 1.26962425184e-05
Gc1_344 0 n2 ns344 0 5.65232446573e-05
Gc1_345 0 n2 ns345 0 -4.02256920003e-07
Gc1_346 0 n2 ns346 0 -3.07320807037e-05
Gc1_347 0 n2 ns347 0 -2.07262905508e-06
Gc1_348 0 n2 ns348 0 -0.000375794374354
Gc1_349 0 n2 ns349 0 -7.0632906778e-06
Gc1_350 0 n2 ns350 0 -1.24587925619e-05
Gc1_351 0 n2 ns351 0 -0.000118784589604
Gc1_352 0 n2 ns352 0 -8.93705048593e-06
Gc1_353 0 n2 ns353 0 -0.0002589419101
Gc1_354 0 n2 ns354 0 -6.97967422553e-05
Gc1_355 0 n2 ns355 0 0.000367741225211
Gc1_356 0 n2 ns356 0 -0.000177307892958
Gc1_357 0 n2 ns357 0 8.25554880056e-05
Gc1_358 0 n2 ns358 0 -3.15353382583e-05
Gc1_359 0 n2 ns359 0 -2.98202543438e-05
Gc1_360 0 n2 ns360 0 -1.24142138434e-05
Gc1_361 0 n2 ns361 0 5.62645874242e-05
Gc1_362 0 n2 ns362 0 0.000138169172625
Gc1_363 0 n2 ns363 0 -0.000468916400114
Gc1_364 0 n2 ns364 0 -0.00113404130185
Gc1_365 0 n2 ns365 0 5.22100564203e-06
Gc1_366 0 n2 ns366 0 -7.26231935099e-06
Gc1_367 0 n2 ns367 0 5.47668411889e-05
Gc1_368 0 n2 ns368 0 -0.000127907569308
Gc1_369 0 n2 ns369 0 1.57498821895e-06
Gc1_370 0 n2 ns370 0 6.02326968328e-08
Gc1_371 0 n2 ns371 0 -0.000682884544304
Gc1_372 0 n2 ns372 0 -0.000438505203209
Gc1_373 0 n2 ns373 0 -0.000245392275151
Gc1_374 0 n2 ns374 0 0.000146283470799
Gc1_375 0 n2 ns375 0 8.28392423857e-06
Gc1_376 0 n2 ns376 0 2.70564300883e-06
Gc1_377 0 n2 ns377 0 1.83113898758e-05
Gc1_378 0 n2 ns378 0 -7.21739256558e-06
Gc1_379 0 n2 ns379 0 7.29339476602e-05
Gc1_380 0 n2 ns380 0 -7.26824236444e-05
Gc1_381 0 n2 ns381 0 -6.73245196711e-05
Gc1_382 0 n2 ns382 0 -0.000172343459247
Gc1_383 0 n2 ns383 0 -1.68116387187e-05
Gc1_384 0 n2 ns384 0 4.74984833669e-05
Gc1_385 0 n2 ns385 0 -0.0120355203687
Gc1_386 0 n2 ns386 0 0.00959744631097
Gc1_387 0 n2 ns387 0 0.00483296969935
Gc1_388 0 n2 ns388 0 0.00313689709544
Gc1_389 0 n2 ns389 0 -0.0112468250686
Gc1_390 0 n2 ns390 0 2.44291841847e-05
Gc1_391 0 n2 ns391 0 -2.82309444976e-05
Gc1_392 0 n2 ns392 0 -1.45784351848e-05
Gc1_393 0 n2 ns393 0 1.65497678656e-08
Gc1_394 0 n2 ns394 0 -1.80154483018e-08
Gc1_395 0 n2 ns395 0 -9.70292304808e-06
Gc1_396 0 n2 ns396 0 -6.59271090763e-06
Gc1_397 0 n2 ns397 0 0.000244303694825
Gc1_398 0 n2 ns398 0 -0.00149580578352
Gc1_399 0 n2 ns399 0 7.75852536346e-07
Gc1_400 0 n2 ns400 0 2.39318944994e-06
Gc1_401 0 n2 ns401 0 0.0021213517642
Gc1_402 0 n2 ns402 0 -0.000632794033453
Gc1_403 0 n2 ns403 0 1.03688465388e-06
Gc1_404 0 n2 ns404 0 3.14749727653e-05
Gc1_405 0 n2 ns405 0 -0.000250952363096
Gc1_406 0 n2 ns406 0 0.00017084661164
Gc1_407 0 n2 ns407 0 -0.00274234564165
Gc1_408 0 n2 ns408 0 -0.000284586770458
Gc1_409 0 n2 ns409 0 -0.00315201358042
Gc1_410 0 n2 ns410 0 0.00441684124708
Gc1_411 0 n2 ns411 0 -4.06570287367e-05
Gc1_412 0 n2 ns412 0 -3.46657996286e-05
Gc1_413 0 n2 ns413 0 -9.0751943787e-06
Gc1_414 0 n2 ns414 0 -2.24816196186e-06
Gc1_415 0 n2 ns415 0 -3.04769248157e-05
Gc1_416 0 n2 ns416 0 -2.88986617855e-05
Gc1_417 0 n2 ns417 0 7.18026944601e-05
Gc1_418 0 n2 ns418 0 -4.11625610831e-05
Gc1_419 0 n2 ns419 0 -0.00139749400954
Gc1_420 0 n2 ns420 0 -0.0025009939042
Gc1_421 0 n2 ns421 0 -2.61303089281e-05
Gc1_422 0 n2 ns422 0 4.6403977828e-05
Gc1_423 0 n2 ns423 0 2.8041034761e-05
Gc1_424 0 n2 ns424 0 -2.97677582669e-05
Gc1_425 0 n2 ns425 0 1.11121799705e-05
Gc1_426 0 n2 ns426 0 1.26078431684e-05
Gc1_427 0 n2 ns427 0 1.82953569302e-05
Gc1_428 0 n2 ns428 0 1.55261279523e-05
Gc1_429 0 n2 ns429 0 4.63705868217e-05
Gc1_430 0 n2 ns430 0 8.64914810756e-06
Gc1_431 0 n2 ns431 0 3.59877612354e-05
Gc1_432 0 n2 ns432 0 -1.6364277714e-05
Gc1_433 0 n2 ns433 0 1.11422916939e-05
Gc1_434 0 n2 ns434 0 -7.77144211131e-06
Gc1_435 0 n2 ns435 0 -1.60494640322e-05
Gc1_436 0 n2 ns436 0 2.78370314842e-05
Gc1_437 0 n2 ns437 0 -3.92525965732e-07
Gc1_438 0 n2 ns438 0 -9.36423582445e-07
Gc1_439 0 n2 ns439 0 3.70545330163e-05
Gc1_440 0 n2 ns440 0 -1.05027962133e-05
Gc1_441 0 n2 ns441 0 3.89487100927e-08
Gc1_442 0 n2 ns442 0 2.32948708856e-06
Gc1_443 0 n2 ns443 0 2.86686832501e-07
Gc1_444 0 n2 ns444 0 7.78133965296e-07
Gc1_445 0 n2 ns445 0 -2.37719942945e-07
Gc1_446 0 n2 ns446 0 2.22717012112e-06
Gc1_447 0 n2 ns447 0 4.18501043695e-07
Gc1_448 0 n2 ns448 0 -3.23781174662e-06
Gc1_449 0 n2 ns449 0 -8.63689197223e-07
Gc1_450 0 n2 ns450 0 -9.50711620636e-07
Gc1_451 0 n2 ns451 0 0.00126627970673
Gc1_452 0 n2 ns452 0 0.0006350575739
Gc1_453 0 n2 ns453 0 -0.00103318992965
Gc1_454 0 n2 ns454 0 -0.000121588472831
Gc1_455 0 n2 ns455 0 -8.35198520894e-05
Gc1_456 0 n2 ns456 0 -2.06256173375e-05
Gc1_457 0 n2 ns457 0 -0.00018553599953
Gc1_458 0 n2 ns458 0 2.63121960914e-05
Gc1_459 0 n2 ns459 0 -7.48817966877e-08
Gc1_460 0 n2 ns460 0 2.16285471834e-08
Gc1_461 0 n2 ns461 0 -9.16828008762e-05
Gc1_462 0 n2 ns462 0 0.000120685914925
Gc1_463 0 n2 ns463 0 -4.14914436554e-05
Gc1_464 0 n2 ns464 0 3.66394033472e-05
Gc1_465 0 n2 ns465 0 5.53468049602e-05
Gc1_466 0 n2 ns466 0 6.1671674662e-05
Gc1_467 0 n2 ns467 0 -8.87014850731e-05
Gc1_468 0 n2 ns468 0 0.000151052998232
Gc1_469 0 n2 ns469 0 -0.000270473606039
Gc1_470 0 n2 ns470 0 2.70590743146e-05
Gc1_471 0 n2 ns471 0 -9.89515854952e-06
Gc1_472 0 n2 ns472 0 6.23172884713e-05
Gc1_473 0 n2 ns473 0 -0.000164359393901
Gc1_474 0 n2 ns474 0 0.000165688290644
Gc1_475 0 n2 ns475 0 2.39855284576e-05
Gc1_476 0 n2 ns476 0 2.52642778717e-07
Gc1_477 0 n2 ns477 0 0.000125283572101
Gc1_478 0 n2 ns478 0 3.16704605669e-05
Gc1_479 0 n2 ns479 0 -0.000635148547326
Gc1_480 0 n2 ns480 0 0.000680106778104
Gc1_481 0 n2 ns481 0 -5.0267518779e-06
Gc1_482 0 n2 ns482 0 2.82488470451e-06
Gc1_483 0 n2 ns483 0 4.44428036418e-06
Gc1_484 0 n2 ns484 0 1.18882445582e-05
Gc1_485 0 n2 ns485 0 -0.000382752395043
Gc1_486 0 n2 ns486 0 9.90574033762e-05
Gc1_487 0 n2 ns487 0 1.81431165138e-05
Gc1_488 0 n2 ns488 0 -2.62281582641e-05
Gc1_489 0 n2 ns489 0 -1.17807970636e-05
Gc1_490 0 n2 ns490 0 9.31699433522e-05
Gc1_491 0 n2 ns491 0 0.000621079946052
Gc1_492 0 n2 ns492 0 0.00133030607755
Gc1_493 0 n2 ns493 0 -0.000136651981314
Gc1_494 0 n2 ns494 0 -5.04096569129e-05
Gc1_495 0 n2 ns495 0 9.21967682363e-06
Gc1_496 0 n2 ns496 0 -1.20301729282e-05
Gc1_497 0 n2 ns497 0 -0.000105245588663
Gc1_498 0 n2 ns498 0 0.000257786039713
Gc1_499 0 n2 ns499 0 5.32619944807e-05
Gc1_500 0 n2 ns500 0 9.50448297984e-05
Gc1_501 0 n2 ns501 0 -0.000108950410611
Gc1_502 0 n2 ns502 0 8.00223182616e-05
Gc1_503 0 n2 ns503 0 4.38859913456e-05
Gc1_504 0 n2 ns504 0 2.25144535085e-05
Gc1_505 0 n2 ns505 0 0.000734691373023
Gc1_506 0 n2 ns506 0 0.000204839143771
Gc1_507 0 n2 ns507 0 -6.12550540989e-05
Gc1_508 0 n2 ns508 0 3.81577389255e-05
Gc1_509 0 n2 ns509 0 5.98094820743e-06
Gc1_510 0 n2 ns510 0 -4.28831031834e-05
Gc1_511 0 n2 ns511 0 -0.000211320846299
Gc1_512 0 n2 ns512 0 0.000104319997231
Gc1_513 0 n2 ns513 0 0.000243054103553
Gc1_514 0 n2 ns514 0 0.00173898964728
Gc1_515 0 n2 ns515 0 6.29917070819e-06
Gc1_516 0 n2 ns516 0 1.44768006583e-05
Gc1_517 0 n2 ns517 0 4.54550088359e-05
Gc1_518 0 n2 ns518 0 -2.38959843019e-05
Gc1_519 0 n2 ns519 0 8.27562456853e-07
Gc1_520 0 n2 ns520 0 -2.18129255363e-08
Gc1_521 0 n2 ns521 0 0.000221846882293
Gc1_522 0 n2 ns522 0 -0.000196938432875
Gc1_523 0 n2 ns523 0 0.000183774647441
Gc1_524 0 n2 ns524 0 -0.000129993948255
Gc1_525 0 n2 ns525 0 9.88854029624e-06
Gc1_526 0 n2 ns526 0 -1.19430264533e-06
Gc1_527 0 n2 ns527 0 -0.00010430936312
Gc1_528 0 n2 ns528 0 2.54643322616e-05
Gc1_529 0 n2 ns529 0 -1.99084550919e-05
Gc1_530 0 n2 ns530 0 0.000176664379686
Gc1_531 0 n2 ns531 0 0.0019275761366
Gc1_532 0 n2 ns532 0 0.0028964115051
Gc1_533 0 n2 ns533 0 3.69218362546e-05
Gc1_534 0 n2 ns534 0 -4.81452325593e-05
Gc1_535 0 n2 ns535 0 -0.0144472128051
Gc1_536 0 n2 ns536 0 -0.00215370391503
Gc1_537 0 n2 ns537 0 -0.00479212080553
Gc1_538 0 n2 ns538 0 0.0069155096219
Gc1_539 0 n2 ns539 0 -0.0110934856454
Gc1_540 0 n2 ns540 0 -2.19645735371e-05
Gc1_541 0 n2 ns541 0 3.94163721019e-05
Gc1_542 0 n2 ns542 0 1.57510791213e-06
Gc1_543 0 n2 ns543 0 6.28342519315e-08
Gc1_544 0 n2 ns544 0 -8.91555658736e-08
Gc1_545 0 n2 ns545 0 4.73542542479e-06
Gc1_546 0 n2 ns546 0 5.79892134201e-06
Gc1_547 0 n2 ns547 0 0.000150866305117
Gc1_548 0 n2 ns548 0 -0.000563904016355
Gc1_549 0 n2 ns549 0 -5.08416212921e-07
Gc1_550 0 n2 ns550 0 -7.05794802486e-07
Gc1_551 0 n2 ns551 0 -0.00147996440294
Gc1_552 0 n2 ns552 0 8.66581683874e-05
Gc1_553 0 n2 ns553 0 6.93620289379e-06
Gc1_554 0 n2 ns554 0 -6.15365385831e-06
Gc1_555 0 n2 ns555 0 -0.000188295245255
Gc1_556 0 n2 ns556 0 9.89926115591e-05
Gc1_557 0 n2 ns557 0 0.00692940937033
Gc1_558 0 n2 ns558 0 0.000463962488786
Gc1_559 0 n2 ns559 0 0.00452937975493
Gc1_560 0 n2 ns560 0 -0.00487704164433
Gc1_561 0 n2 ns561 0 1.01156876018e-05
Gc1_562 0 n2 ns562 0 4.11851854356e-05
Gc1_563 0 n2 ns563 0 -1.18674367487e-05
Gc1_564 0 n2 ns564 0 -9.40622319978e-06
Gc1_565 0 n2 ns565 0 -3.07020107858e-05
Gc1_566 0 n2 ns566 0 -5.2240350014e-05
Gc1_567 0 n2 ns567 0 -0.000276154863099
Gc1_568 0 n2 ns568 0 -0.00010755810711
Gc1_569 0 n2 ns569 0 0.000417678843476
Gc1_570 0 n2 ns570 0 -0.00242441736403
Gc1_571 0 n2 ns571 0 -2.34670115731e-05
Gc1_572 0 n2 ns572 0 -3.21040246067e-05
Gc1_573 0 n2 ns573 0 -3.19553687629e-07
Gc1_574 0 n2 ns574 0 -4.47791522883e-05
Gc1_575 0 n2 ns575 0 4.1274830468e-06
Gc1_576 0 n2 ns576 0 -2.14428181557e-05
Gc1_577 0 n2 ns577 0 -1.59756499042e-06
Gc1_578 0 n2 ns578 0 -1.33760935653e-05
Gc1_579 0 n2 ns579 0 -3.68176953164e-06
Gc1_580 0 n2 ns580 0 -2.49356768414e-05
Gc1_581 0 n2 ns581 0 -7.02309954251e-05
Gc1_582 0 n2 ns582 0 4.3424179515e-06
Gc1_583 0 n2 ns583 0 1.11872387907e-06
Gc1_584 0 n2 ns584 0 1.09452266263e-06
Gc1_585 0 n2 ns585 0 2.28079629354e-05
Gc1_586 0 n2 ns586 0 -5.28802563893e-06
Gc1_587 0 n2 ns587 0 -1.6607642944e-06
Gc1_588 0 n2 ns588 0 3.88497266734e-07
Gc1_589 0 n2 ns589 0 2.93678054709e-05
Gc1_590 0 n2 ns590 0 4.00731656817e-05
Gc1_591 0 n2 ns591 0 4.76342514825e-06
Gc1_592 0 n2 ns592 0 -4.4665245194e-07
Gc1_593 0 n2 ns593 0 6.67522882955e-07
Gc1_594 0 n2 ns594 0 -1.46630462557e-06
Gc1_595 0 n2 ns595 0 1.64697217774e-06
Gc1_596 0 n2 ns596 0 3.59138895898e-06
Gc1_597 0 n2 ns597 0 5.86362312387e-06
Gc1_598 0 n2 ns598 0 -1.01975283114e-05
Gc1_599 0 n2 ns599 0 6.89081871602e-07
Gc1_600 0 n2 ns600 0 -3.05443649374e-06
Gc1_601 0 n2 ns601 0 0.000559226221957
Gc1_602 0 n2 ns602 0 0.000347046769425
Gc1_603 0 n2 ns603 0 0.000296997963658
Gc1_604 0 n2 ns604 0 -0.000138077474236
Gc1_605 0 n2 ns605 0 -2.49294902811e-05
Gc1_606 0 n2 ns606 0 2.47228746871e-05
Gc1_607 0 n2 ns607 0 0.000102873658554
Gc1_608 0 n2 ns608 0 -4.6972726671e-05
Gc1_609 0 n2 ns609 0 -9.15063955866e-09
Gc1_610 0 n2 ns610 0 1.62875452285e-08
Gc1_611 0 n2 ns611 0 -3.59424627178e-05
Gc1_612 0 n2 ns612 0 3.812251324e-05
Gc1_613 0 n2 ns613 0 2.09854044023e-05
Gc1_614 0 n2 ns614 0 -4.8635866757e-05
Gc1_615 0 n2 ns615 0 -4.19514164956e-05
Gc1_616 0 n2 ns616 0 -0.000145883015343
Gc1_617 0 n2 ns617 0 1.44152487978e-05
Gc1_618 0 n2 ns618 0 9.32656577383e-05
Gc1_619 0 n2 ns619 0 -0.00020598253131
Gc1_620 0 n2 ns620 0 -1.99501523965e-06
Gc1_621 0 n2 ns621 0 2.93342243837e-05
Gc1_622 0 n2 ns622 0 -9.89107914102e-05
Gc1_623 0 n2 ns623 0 -1.7030409533e-05
Gc1_624 0 n2 ns624 0 0.0003697127704
Gc1_625 0 n2 ns625 0 5.33937355463e-06
Gc1_626 0 n2 ns626 0 1.07035957701e-06
Gc1_627 0 n2 ns627 0 1.41891434954e-05
Gc1_628 0 n2 ns628 0 -3.81800296528e-05
Gc1_629 0 n2 ns629 0 0.000398198000374
Gc1_630 0 n2 ns630 0 -8.02621554433e-06
Gc1_631 0 n2 ns631 0 1.17789949752e-06
Gc1_632 0 n2 ns632 0 -1.84819243484e-06
Gc1_633 0 n2 ns633 0 -5.15988198029e-07
Gc1_634 0 n2 ns634 0 1.80517501555e-06
Gc1_635 0 n2 ns635 0 -0.00027667627998
Gc1_636 0 n2 ns636 0 -0.000346799570709
Gc1_637 0 n2 ns637 0 3.42293300659e-05
Gc1_638 0 n2 ns638 0 1.45047008052e-05
Gc1_639 0 n2 ns639 0 -7.83318987717e-05
Gc1_640 0 n2 ns640 0 3.39584054068e-05
Gc1_641 0 n2 ns641 0 -1.36885780442e-05
Gc1_642 0 n2 ns642 0 0.00047796362548
Gc1_643 0 n2 ns643 0 3.69854737055e-05
Gc1_644 0 n2 ns644 0 -4.48198525102e-05
Gc1_645 0 n2 ns645 0 1.02776297269e-05
Gc1_646 0 n2 ns646 0 -7.27960284954e-06
Gc1_647 0 n2 ns647 0 8.06916548722e-05
Gc1_648 0 n2 ns648 0 -0.00014182536775
Gc1_649 0 n2 ns649 0 5.01932331845e-05
Gc1_650 0 n2 ns650 0 -8.60246649579e-06
Gc1_651 0 n2 ns651 0 -1.11542374723e-05
Gc1_652 0 n2 ns652 0 8.86696458833e-05
Gc1_653 0 n2 ns653 0 -7.08648466023e-05
Gc1_654 0 n2 ns654 0 9.38985509745e-05
Gc1_655 0 n2 ns655 0 0.000253601434762
Gc1_656 0 n2 ns656 0 8.53317483625e-05
Gc1_657 0 n2 ns657 0 1.85681981786e-05
Gc1_658 0 n2 ns658 0 -1.11769020062e-05
Gc1_659 0 n2 ns659 0 -3.39304967036e-05
Gc1_660 0 n2 ns660 0 -1.03539679848e-07
Gc1_661 0 n2 ns661 0 9.72213452035e-05
Gc1_662 0 n2 ns662 0 0.000127298588125
Gc1_663 0 n2 ns663 0 0.000363846434344
Gc1_664 0 n2 ns664 0 -0.000233815169923
Gc1_665 0 n2 ns665 0 7.22471784102e-06
Gc1_666 0 n2 ns666 0 9.49374549544e-10
Gc1_667 0 n2 ns667 0 3.2715828028e-05
Gc1_668 0 n2 ns668 0 -5.16029418047e-05
Gc1_669 0 n2 ns669 0 3.49879810801e-07
Gc1_670 0 n2 ns670 0 2.97561626605e-07
Gc1_671 0 n2 ns671 0 0.000203460695487
Gc1_672 0 n2 ns672 0 5.59420984916e-05
Gc1_673 0 n2 ns673 0 0.000257241113482
Gc1_674 0 n2 ns674 0 -6.49360119231e-05
Gc1_675 0 n2 ns675 0 8.50265149839e-06
Gc1_676 0 n2 ns676 0 1.00245125838e-05
Gc1_677 0 n2 ns677 0 2.41162388391e-05
Gc1_678 0 n2 ns678 0 5.15626254988e-05
Gc1_679 0 n2 ns679 0 0.000125927057401
Gc1_680 0 n2 ns680 0 -3.64876150711e-05
Gc1_681 0 n2 ns681 0 0.000312255689342
Gc1_682 0 n2 ns682 0 -0.00141086926419
Gc1_683 0 n2 ns683 0 -2.96400704986e-05
Gc1_684 0 n2 ns684 0 1.82654287867e-05
Gc1_685 0 n2 ns685 0 -0.00216075174713
Gc1_686 0 n2 ns686 0 0.00665046500296
Gc1_687 0 n2 ns687 0 0.00253040699045
Gc1_688 0 n2 ns688 0 -0.000323625148799
Gc1_689 0 n2 ns689 0 -0.00663420241078
Gc1_690 0 n2 ns690 0 -7.13674232453e-07
Gc1_691 0 n2 ns691 0 -1.15720826811e-05
Gc1_692 0 n2 ns692 0 -2.61983640532e-05
Gc1_693 0 n2 ns693 0 -2.39708246127e-07
Gc1_694 0 n2 ns694 0 -6.62159210404e-08
Gc1_695 0 n2 ns695 0 -5.38010202828e-06
Gc1_696 0 n2 ns696 0 -3.1150657178e-06
Gc1_697 0 n2 ns697 0 5.93287457118e-05
Gc1_698 0 n2 ns698 0 -0.00110807002104
Gc1_699 0 n2 ns699 0 -4.0781046423e-07
Gc1_700 0 n2 ns700 0 9.44231865927e-07
Gc1_701 0 n2 ns701 0 0.00202535566826
Gc1_702 0 n2 ns702 0 -0.00100248688721
Gc1_703 0 n2 ns703 0 -9.53794334503e-06
Gc1_704 0 n2 ns704 0 4.13892074239e-05
Gc1_705 0 n2 ns705 0 -0.000238426892107
Gc1_706 0 n2 ns706 0 7.87825890606e-05
Gc1_707 0 n2 ns707 0 -0.00213448726789
Gc1_708 0 n2 ns708 0 -6.83578229918e-05
Gc1_709 0 n2 ns709 0 0.000317127865649
Gc1_710 0 n2 ns710 0 0.00444730493782
Gc1_711 0 n2 ns711 0 -2.12439640229e-05
Gc1_712 0 n2 ns712 0 -4.11525389322e-05
Gc1_713 0 n2 ns713 0 -4.28900937728e-06
Gc1_714 0 n2 ns714 0 -7.17938819182e-06
Gc1_715 0 n2 ns715 0 -1.16091678458e-05
Gc1_716 0 n2 ns716 0 -3.04271436271e-05
Gc1_717 0 n2 ns717 0 5.78751840039e-05
Gc1_718 0 n2 ns718 0 4.30702948715e-05
Gc1_719 0 n2 ns719 0 -0.00178693052907
Gc1_720 0 n2 ns720 0 -0.00120993774579
Gc1_721 0 n2 ns721 0 -4.01487284298e-05
Gc1_722 0 n2 ns722 0 5.5653108328e-05
Gc1_723 0 n2 ns723 0 2.44807163493e-05
Gc1_724 0 n2 ns724 0 -2.45828076663e-05
Gc1_725 0 n2 ns725 0 -4.2638409949e-06
Gc1_726 0 n2 ns726 0 7.42648629898e-06
Gc1_727 0 n2 ns727 0 9.45280054286e-06
Gc1_728 0 n2 ns728 0 7.68126366307e-06
Gc1_729 0 n2 ns729 0 4.61451320421e-05
Gc1_730 0 n2 ns730 0 8.76537557082e-06
Gc1_731 0 n2 ns731 0 7.27190975603e-05
Gc1_732 0 n2 ns732 0 3.64525819823e-06
Gc1_733 0 n2 ns733 0 1.83802527502e-05
Gc1_734 0 n2 ns734 0 5.80521884187e-06
Gc1_735 0 n2 ns735 0 -1.40097374172e-05
Gc1_736 0 n2 ns736 0 8.40026643132e-06
Gc1_737 0 n2 ns737 0 -7.8517195374e-07
Gc1_738 0 n2 ns738 0 -1.18638227279e-06
Gc1_739 0 n2 ns739 0 3.91010971277e-06
Gc1_740 0 n2 ns740 0 -2.71474003536e-05
Gc1_741 0 n2 ns741 0 -6.64681777424e-07
Gc1_742 0 n2 ns742 0 2.23051772824e-07
Gc1_743 0 n2 ns743 0 -3.85290618885e-07
Gc1_744 0 n2 ns744 0 4.86620754023e-07
Gc1_745 0 n2 ns745 0 -5.63726648411e-07
Gc1_746 0 n2 ns746 0 -3.85771487339e-07
Gc1_747 0 n2 ns747 0 -1.13987859296e-06
Gc1_748 0 n2 ns748 0 6.55537322383e-07
Gc1_749 0 n2 ns749 0 9.77005339416e-07
Gc1_750 0 n2 ns750 0 1.35984168363e-06
Gc1_751 0 n2 ns751 0 0.00319458910459
Gc1_752 0 n2 ns752 0 -0.00149710121956
Gc1_753 0 n2 ns753 0 -0.00138634407584
Gc1_754 0 n2 ns754 0 -0.000326413728636
Gc1_755 0 n2 ns755 0 0.000275253393561
Gc1_756 0 n2 ns756 0 4.10290904635e-05
Gc1_757 0 n2 ns757 0 -0.000221178779415
Gc1_758 0 n2 ns758 0 0.00018513071539
Gc1_759 0 n2 ns759 0 -3.32686947726e-08
Gc1_760 0 n2 ns760 0 -9.53699029909e-08
Gc1_761 0 n2 ns761 0 -0.000180576154201
Gc1_762 0 n2 ns762 0 -5.99263372554e-05
Gc1_763 0 n2 ns763 0 -5.83928261684e-05
Gc1_764 0 n2 ns764 0 -0.000106841229032
Gc1_765 0 n2 ns765 0 -3.7128704813e-05
Gc1_766 0 n2 ns766 0 -0.000176104330856
Gc1_767 0 n2 ns767 0 0.000126030184103
Gc1_768 0 n2 ns768 0 0.000174085941619
Gc1_769 0 n2 ns769 0 -0.000278014998143
Gc1_770 0 n2 ns770 0 0.00032024390968
Gc1_771 0 n2 ns771 0 8.74861127638e-05
Gc1_772 0 n2 ns772 0 0.000163941456532
Gc1_773 0 n2 ns773 0 -0.000668610400906
Gc1_774 0 n2 ns774 0 -0.000285113845053
Gc1_775 0 n2 ns775 0 1.76736525966e-05
Gc1_776 0 n2 ns776 0 1.08348493937e-05
Gc1_777 0 n2 ns777 0 1.13214495773e-05
Gc1_778 0 n2 ns778 0 -0.00016346783019
Gc1_779 0 n2 ns779 0 0.000189447069636
Gc1_780 0 n2 ns780 0 0.00103552863586
Gc1_781 0 n2 ns781 0 -1.00028763818e-06
Gc1_782 0 n2 ns782 0 -5.53511526984e-07
Gc1_783 0 n2 ns783 0 5.97231921585e-06
Gc1_784 0 n2 ns784 0 1.20954349239e-05
Gc1_785 0 n2 ns785 0 -0.000633576159047
Gc1_786 0 n2 ns786 0 0.000448435698451
Gc1_787 0 n2 ns787 0 3.36646837327e-05
Gc1_788 0 n2 ns788 0 -2.61747731202e-05
Gc1_789 0 n2 ns789 0 9.53025416191e-06
Gc1_790 0 n2 ns790 0 7.155466015e-07
Gc1_791 0 n2 ns791 0 0.000613814985373
Gc1_792 0 n2 ns792 0 -3.22611207365e-05
Gc1_793 0 n2 ns793 0 -5.43676176136e-05
Gc1_794 0 n2 ns794 0 9.89271851199e-05
Gc1_795 0 n2 ns795 0 -1.52476452049e-06
Gc1_796 0 n2 ns796 0 -8.41155542881e-06
Gc1_797 0 n2 ns797 0 0.000125881001389
Gc1_798 0 n2 ns798 0 0.00032945938697
Gc1_799 0 n2 ns799 0 0.000130476565201
Gc1_800 0 n2 ns800 0 9.60665643297e-05
Gc1_801 0 n2 ns801 0 -0.000205555072046
Gc1_802 0 n2 ns802 0 0.000291216229347
Gc1_803 0 n2 ns803 0 -0.000142567800435
Gc1_804 0 n2 ns804 0 7.26627542871e-05
Gc1_805 0 n2 ns805 0 0.000147381037279
Gc1_806 0 n2 ns806 0 -0.000473800407227
Gc1_807 0 n2 ns807 0 -1.92076104861e-05
Gc1_808 0 n2 ns808 0 4.41505750632e-05
Gc1_809 0 n2 ns809 0 1.69768157292e-05
Gc1_810 0 n2 ns810 0 -2.53675603042e-05
Gc1_811 0 n2 ns811 0 -0.000133060548757
Gc1_812 0 n2 ns812 0 6.02104114961e-05
Gc1_813 0 n2 ns813 0 0.00124258689546
Gc1_814 0 n2 ns814 0 0.00116909888845
Gc1_815 0 n2 ns815 0 1.09417119776e-05
Gc1_816 0 n2 ns816 0 6.48098701713e-06
Gc1_817 0 n2 ns817 0 4.84497841629e-05
Gc1_818 0 n2 ns818 0 -5.4858893318e-05
Gc1_819 0 n2 ns819 0 1.31279443932e-06
Gc1_820 0 n2 ns820 0 5.5857051571e-08
Gc1_821 0 n2 ns821 0 -0.000407897644777
Gc1_822 0 n2 ns822 0 -0.000542590671268
Gc1_823 0 n2 ns823 0 -0.000255996996576
Gc1_824 0 n2 ns824 0 -7.79161921369e-05
Gc1_825 0 n2 ns825 0 8.88380267715e-06
Gc1_826 0 n2 ns826 0 -1.11907128053e-05
Gc1_827 0 n2 ns827 0 -7.01648428401e-05
Gc1_828 0 n2 ns828 0 9.05755791447e-06
Gc1_829 0 n2 ns829 0 -1.57086248217e-05
Gc1_830 0 n2 ns830 0 0.000113401535758
Gc1_831 0 n2 ns831 0 0.00209755415267
Gc1_832 0 n2 ns832 0 0.000847966312285
Gc1_833 0 n2 ns833 0 2.00866812119e-05
Gc1_834 0 n2 ns834 0 -5.80763823043e-05
Gc1_835 0 n2 ns835 0 -0.0133135725779
Gc1_836 0 n2 ns836 0 0.00324622948164
Gc1_837 0 n2 ns837 0 -0.00313093503678
Gc1_838 0 n2 ns838 0 0.00162629115597
Gc1_839 0 n2 ns839 0 -0.0102344657612
Gc1_840 0 n2 ns840 0 3.87221296871e-06
Gc1_841 0 n2 ns841 0 4.17783744224e-05
Gc1_842 0 n2 ns842 0 -1.22889439557e-05
Gc1_843 0 n2 ns843 0 -2.53203887127e-08
Gc1_844 0 n2 ns844 0 -1.38529301235e-07
Gc1_845 0 n2 ns845 0 6.52518343658e-06
Gc1_846 0 n2 ns846 0 6.038663792e-06
Gc1_847 0 n2 ns847 0 -0.000161166254039
Gc1_848 0 n2 ns848 0 -0.000410662161161
Gc1_849 0 n2 ns849 0 -8.90507826324e-07
Gc1_850 0 n2 ns850 0 -1.11669413175e-06
Gc1_851 0 n2 ns851 0 -0.00152153654392
Gc1_852 0 n2 ns852 0 0.000173849020209
Gc1_853 0 n2 ns853 0 1.37115731125e-05
Gc1_854 0 n2 ns854 0 -7.40034089157e-06
Gc1_855 0 n2 ns855 0 -0.00017511660934
Gc1_856 0 n2 ns856 0 0.000151248576581
Gc1_857 0 n2 ns857 0 0.00288603419088
Gc1_858 0 n2 ns858 0 -0.00229490933061
Gc1_859 0 n2 ns859 0 -0.000749598234765
Gc1_860 0 n2 ns860 0 -0.0043848361977
Gc1_861 0 n2 ns861 0 -2.53537209849e-06
Gc1_862 0 n2 ns862 0 3.06235963052e-05
Gc1_863 0 n2 ns863 0 -1.19463976675e-05
Gc1_864 0 n2 ns864 0 -5.91798044589e-06
Gc1_865 0 n2 ns865 0 -3.45161462583e-05
Gc1_866 0 n2 ns866 0 -5.51669010067e-05
Gc1_867 0 n2 ns867 0 -0.000207438328118
Gc1_868 0 n2 ns868 0 -6.83456109685e-05
Gc1_869 0 n2 ns869 0 -0.00067221067055
Gc1_870 0 n2 ns870 0 -0.00176869989938
Gc1_871 0 n2 ns871 0 -4.41067777748e-05
Gc1_872 0 n2 ns872 0 -3.44673311302e-05
Gc1_873 0 n2 ns873 0 -1.29865673459e-05
Gc1_874 0 n2 ns874 0 -4.25232063851e-05
Gc1_875 0 n2 ns875 0 1.9023100204e-06
Gc1_876 0 n2 ns876 0 -2.32158851722e-05
Gc1_877 0 n2 ns877 0 -4.11258239157e-06
Gc1_878 0 n2 ns878 0 -1.77938170219e-05
Gc1_879 0 n2 ns879 0 -4.82558814591e-06
Gc1_880 0 n2 ns880 0 -3.03946343583e-05
Gc1_881 0 n2 ns881 0 -5.53138685387e-05
Gc1_882 0 n2 ns882 0 1.88457527412e-05
Gc1_883 0 n2 ns883 0 2.58852353848e-06
Gc1_884 0 n2 ns884 0 7.99798710098e-06
Gc1_885 0 n2 ns885 0 2.44663480144e-05
Gc1_886 0 n2 ns886 0 -1.36299332134e-05
Gc1_887 0 n2 ns887 0 -1.28893854808e-06
Gc1_888 0 n2 ns888 0 2.31738844978e-07
Gc1_889 0 n2 ns889 0 3.5246908158e-05
Gc1_890 0 n2 ns890 0 7.67759096862e-06
Gc1_891 0 n2 ns891 0 1.49008138601e-06
Gc1_892 0 n2 ns892 0 -2.02468762168e-06
Gc1_893 0 n2 ns893 0 -5.32387543041e-07
Gc1_894 0 n2 ns894 0 -1.0561921001e-06
Gc1_895 0 n2 ns895 0 1.79894149044e-06
Gc1_896 0 n2 ns896 0 -6.11226115427e-08
Gc1_897 0 n2 ns897 0 -4.53283554544e-07
Gc1_898 0 n2 ns898 0 -8.78864781701e-06
Gc1_899 0 n2 ns899 0 -1.50820789307e-06
Gc1_900 0 n2 ns900 0 -1.32168244547e-06
Gd1_1 0 n2 ni1 0 -0.00817261933988
Gd1_2 0 n2 ni2 0 0.000144410145072
Gd1_3 0 n2 ni3 0 0.000871080628863
Gd1_4 0 n2 ni4 0 0.000761602860772
Gd1_5 0 n2 ni5 0 0.000926040474809
Gd1_6 0 n2 ni6 0 0.00100552128407
Gc2_1 0 n4 ns1 0 -0.00046890018424
Gc2_2 0 n4 ns2 0 0.00343934035392
Gc2_3 0 n4 ns3 0 -0.000301458583839
Gc2_4 0 n4 ns4 0 -3.70146639628e-05
Gc2_5 0 n4 ns5 0 0.000132374356849
Gc2_6 0 n4 ns6 0 -0.000194549750403
Gc2_7 0 n4 ns7 0 -4.58688528476e-05
Gc2_8 0 n4 ns8 0 5.77728980996e-05
Gc2_9 0 n4 ns9 0 5.54215759119e-09
Gc2_10 0 n4 ns10 0 -9.20228941406e-10
Gc2_11 0 n4 ns11 0 -0.000152843346068
Gc2_12 0 n4 ns12 0 9.80150760254e-05
Gc2_13 0 n4 ns13 0 7.97881605096e-06
Gc2_14 0 n4 ns14 0 2.75001209273e-05
Gc2_15 0 n4 ns15 0 -2.46546135356e-05
Gc2_16 0 n4 ns16 0 -8.61231274068e-05
Gc2_17 0 n4 ns17 0 -1.80797738376e-06
Gc2_18 0 n4 ns18 0 -0.000171914396581
Gc2_19 0 n4 ns19 0 9.99371496646e-05
Gc2_20 0 n4 ns20 0 -6.65707020648e-05
Gc2_21 0 n4 ns21 0 2.88329691053e-05
Gc2_22 0 n4 ns22 0 -1.82495393923e-05
Gc2_23 0 n4 ns23 0 -0.000583879514452
Gc2_24 0 n4 ns24 0 0.000100760458782
Gc2_25 0 n4 ns25 0 1.66385220511e-05
Gc2_26 0 n4 ns26 0 1.57532805743e-05
Gc2_27 0 n4 ns27 0 -2.92801656018e-05
Gc2_28 0 n4 ns28 0 -1.34421531956e-05
Gc2_29 0 n4 ns29 0 -0.000148531187279
Gc2_30 0 n4 ns30 0 -0.000446879554654
Gc2_31 0 n4 ns31 0 8.72061566155e-07
Gc2_32 0 n4 ns32 0 -4.09291007505e-06
Gc2_33 0 n4 ns33 0 -3.63087920438e-06
Gc2_34 0 n4 ns34 0 2.73105507808e-07
Gc2_35 0 n4 ns35 0 -0.000304204355425
Gc2_36 0 n4 ns36 0 0.000230565522458
Gc2_37 0 n4 ns37 0 2.31746071722e-05
Gc2_38 0 n4 ns38 0 -2.29067205759e-05
Gc2_39 0 n4 ns39 0 -5.79444993616e-05
Gc2_40 0 n4 ns40 0 2.75471106644e-05
Gc2_41 0 n4 ns41 0 -0.00115183994658
Gc2_42 0 n4 ns42 0 0.000239543133491
Gc2_43 0 n4 ns43 0 1.93182285416e-05
Gc2_44 0 n4 ns44 0 -7.04391757931e-06
Gc2_45 0 n4 ns45 0 -7.6383898676e-08
Gc2_46 0 n4 ns46 0 5.9246679813e-06
Gc2_47 0 n4 ns47 0 -0.000104831140452
Gc2_48 0 n4 ns48 0 4.16273985992e-05
Gc2_49 0 n4 ns49 0 5.07308502296e-06
Gc2_50 0 n4 ns50 0 7.21651389041e-05
Gc2_51 0 n4 ns51 0 -5.08111681667e-05
Gc2_52 0 n4 ns52 0 0.000158623139319
Gc2_53 0 n4 ns53 0 -3.9351017986e-05
Gc2_54 0 n4 ns54 0 0.000308553075752
Gc2_55 0 n4 ns55 0 -0.000430068908404
Gc2_56 0 n4 ns56 0 0.000651400175435
Gc2_57 0 n4 ns57 0 -5.38010986186e-05
Gc2_58 0 n4 ns58 0 -4.02905187599e-05
Gc2_59 0 n4 ns59 0 5.18544378407e-05
Gc2_60 0 n4 ns60 0 -2.62176478346e-05
Gc2_61 0 n4 ns61 0 -0.000231552168807
Gc2_62 0 n4 ns62 0 -0.000140960097516
Gc2_63 0 n4 ns63 0 -0.000879438783951
Gc2_64 0 n4 ns64 0 0.000280748076432
Gc2_65 0 n4 ns65 0 -2.83255733104e-06
Gc2_66 0 n4 ns66 0 6.92713704259e-06
Gc2_67 0 n4 ns67 0 6.19710623629e-05
Gc2_68 0 n4 ns68 0 -1.30948073611e-05
Gc2_69 0 n4 ns69 0 7.54075442011e-07
Gc2_70 0 n4 ns70 0 5.18445043153e-07
Gc2_71 0 n4 ns71 0 -0.000931160344085
Gc2_72 0 n4 ns72 0 0.000270047166525
Gc2_73 0 n4 ns73 0 -9.82171942555e-06
Gc2_74 0 n4 ns74 0 0.000959901048991
Gc2_75 0 n4 ns75 0 -9.73154396693e-06
Gc2_76 0 n4 ns76 0 -3.06568552759e-06
Gc2_77 0 n4 ns77 0 -0.000201963403466
Gc2_78 0 n4 ns78 0 -8.43078638946e-05
Gc2_79 0 n4 ns79 0 -0.00021085287996
Gc2_80 0 n4 ns80 0 0.000259203974467
Gc2_81 0 n4 ns81 0 -0.00204024402193
Gc2_82 0 n4 ns82 0 0.00255083430343
Gc2_83 0 n4 ns83 0 4.40537365354e-05
Gc2_84 0 n4 ns84 0 -1.59035013439e-05
Gc2_85 0 n4 ns85 0 0.0437523350841
Gc2_86 0 n4 ns86 0 0.014789757091
Gc2_87 0 n4 ns87 0 -0.0101923897485
Gc2_88 0 n4 ns88 0 0.0116913823011
Gc2_89 0 n4 ns89 0 0.00961470037709
Gc2_90 0 n4 ns90 0 -0.000131794471341
Gc2_91 0 n4 ns91 0 2.48162894697e-05
Gc2_92 0 n4 ns92 0 1.24978560965e-05
Gc2_93 0 n4 ns93 0 2.78646899351e-07
Gc2_94 0 n4 ns94 0 3.35199466859e-07
Gc2_95 0 n4 ns95 0 5.71822056779e-06
Gc2_96 0 n4 ns96 0 6.25908100572e-06
Gc2_97 0 n4 ns97 0 0.000464728470745
Gc2_98 0 n4 ns98 0 0.000258625394722
Gc2_99 0 n4 ns99 0 -9.90722782419e-07
Gc2_100 0 n4 ns100 0 -2.69904951431e-07
Gc2_101 0 n4 ns101 0 -0.00318456000778
Gc2_102 0 n4 ns102 0 -0.000881836350612
Gc2_103 0 n4 ns103 0 4.77698038548e-05
Gc2_104 0 n4 ns104 0 -4.94319762065e-06
Gc2_105 0 n4 ns105 0 -0.000128309424805
Gc2_106 0 n4 ns106 0 0.000117272324177
Gc2_107 0 n4 ns107 0 -0.000894061412816
Gc2_108 0 n4 ns108 0 0.0109896050569
Gc2_109 0 n4 ns109 0 0.00975447880562
Gc2_110 0 n4 ns110 0 0.0169386323792
Gc2_111 0 n4 ns111 0 -3.79118176057e-05
Gc2_112 0 n4 ns112 0 7.40512306581e-05
Gc2_113 0 n4 ns113 0 5.41293783656e-06
Gc2_114 0 n4 ns114 0 -7.80377057317e-06
Gc2_115 0 n4 ns115 0 -2.21380631609e-05
Gc2_116 0 n4 ns116 0 -7.97823990121e-05
Gc2_117 0 n4 ns117 0 -0.00011887592727
Gc2_118 0 n4 ns118 0 -0.000330695601048
Gc2_119 0 n4 ns119 0 0.00226985288043
Gc2_120 0 n4 ns120 0 0.00202003309376
Gc2_121 0 n4 ns121 0 -1.63742331845e-06
Gc2_122 0 n4 ns122 0 1.54149939148e-05
Gc2_123 0 n4 ns123 0 1.56668497145e-05
Gc2_124 0 n4 ns124 0 -1.23645890197e-05
Gc2_125 0 n4 ns125 0 2.00997985223e-05
Gc2_126 0 n4 ns126 0 -9.49201881723e-06
Gc2_127 0 n4 ns127 0 -2.556786887e-06
Gc2_128 0 n4 ns128 0 -5.59732563552e-06
Gc2_129 0 n4 ns129 0 -6.82654990875e-06
Gc2_130 0 n4 ns130 0 -1.92957143921e-05
Gc2_131 0 n4 ns131 0 -6.40283311204e-05
Gc2_132 0 n4 ns132 0 -1.54704392827e-05
Gc2_133 0 n4 ns133 0 5.37999628997e-06
Gc2_134 0 n4 ns134 0 2.58198848984e-06
Gc2_135 0 n4 ns135 0 1.79683276679e-05
Gc2_136 0 n4 ns136 0 -1.56321189542e-06
Gc2_137 0 n4 ns137 0 6.46228253287e-07
Gc2_138 0 n4 ns138 0 -2.02356906621e-07
Gc2_139 0 n4 ns139 0 2.40834498957e-06
Gc2_140 0 n4 ns140 0 -1.86224179468e-05
Gc2_141 0 n4 ns141 0 -4.83661405604e-07
Gc2_142 0 n4 ns142 0 -8.93385905648e-06
Gc2_143 0 n4 ns143 0 -1.23474276885e-06
Gc2_144 0 n4 ns144 0 -2.02729417386e-06
Gc2_145 0 n4 ns145 0 2.64704754709e-06
Gc2_146 0 n4 ns146 0 -5.86795088487e-06
Gc2_147 0 n4 ns147 0 -5.54253227157e-06
Gc2_148 0 n4 ns148 0 1.63053975038e-06
Gc2_149 0 n4 ns149 0 -3.09051398814e-06
Gc2_150 0 n4 ns150 0 1.53465869593e-06
Gc2_151 0 n4 ns151 0 -0.00573583905294
Gc2_152 0 n4 ns152 0 0.00225593198176
Gc2_153 0 n4 ns153 0 -0.000911703407931
Gc2_154 0 n4 ns154 0 -0.00106445770359
Gc2_155 0 n4 ns155 0 0.000229308829439
Gc2_156 0 n4 ns156 0 -8.65174859165e-05
Gc2_157 0 n4 ns157 0 -0.000145689107367
Gc2_158 0 n4 ns158 0 4.95850943874e-05
Gc2_159 0 n4 ns159 0 8.63593185433e-08
Gc2_160 0 n4 ns160 0 -7.74368279484e-08
Gc2_161 0 n4 ns161 0 -2.22916611818e-05
Gc2_162 0 n4 ns162 0 6.88066558002e-05
Gc2_163 0 n4 ns163 0 5.50726776509e-05
Gc2_164 0 n4 ns164 0 9.3091773203e-05
Gc2_165 0 n4 ns165 0 0.000143202403886
Gc2_166 0 n4 ns166 0 5.07661586165e-05
Gc2_167 0 n4 ns167 0 0.000202183858483
Gc2_168 0 n4 ns168 0 -2.76485991246e-05
Gc2_169 0 n4 ns169 0 0.000151384252278
Gc2_170 0 n4 ns170 0 -0.000143010441518
Gc2_171 0 n4 ns171 0 -1.94894398174e-05
Gc2_172 0 n4 ns172 0 1.5372463849e-05
Gc2_173 0 n4 ns173 0 -0.00025481866678
Gc2_174 0 n4 ns174 0 -0.000305219333879
Gc2_175 0 n4 ns175 0 2.4383182722e-05
Gc2_176 0 n4 ns176 0 1.66904532537e-05
Gc2_177 0 n4 ns177 0 -6.86238384049e-05
Gc2_178 0 n4 ns178 0 0.000113309375516
Gc2_179 0 n4 ns179 0 -0.000209225140821
Gc2_180 0 n4 ns180 0 -0.000554558208523
Gc2_181 0 n4 ns181 0 5.12152825249e-06
Gc2_182 0 n4 ns182 0 -4.12595038713e-06
Gc2_183 0 n4 ns183 0 1.0575736969e-05
Gc2_184 0 n4 ns184 0 1.82016848744e-05
Gc2_185 0 n4 ns185 0 -0.00026463401099
Gc2_186 0 n4 ns186 0 8.47083954622e-05
Gc2_187 0 n4 ns187 0 -1.12440639992e-05
Gc2_188 0 n4 ns188 0 -1.00360899341e-05
Gc2_189 0 n4 ns189 0 4.85902026308e-05
Gc2_190 0 n4 ns190 0 -1.34812915135e-05
Gc2_191 0 n4 ns191 0 6.57486946794e-05
Gc2_192 0 n4 ns192 0 -0.000135595976661
Gc2_193 0 n4 ns193 0 2.30404547709e-05
Gc2_194 0 n4 ns194 0 2.5463524586e-05
Gc2_195 0 n4 ns195 0 -1.39081088312e-05
Gc2_196 0 n4 ns196 0 1.67687699242e-05
Gc2_197 0 n4 ns197 0 1.2360496223e-05
Gc2_198 0 n4 ns198 0 -3.18674904103e-05
Gc2_199 0 n4 ns199 0 2.8076812456e-05
Gc2_200 0 n4 ns200 0 1.99406363334e-05
Gc2_201 0 n4 ns201 0 -3.94056864155e-05
Gc2_202 0 n4 ns202 0 0.000112999765065
Gc2_203 0 n4 ns203 0 -5.32655523456e-06
Gc2_204 0 n4 ns204 0 -2.03661061078e-05
Gc2_205 0 n4 ns205 0 0.000389067405506
Gc2_206 0 n4 ns206 0 0.000253792123903
Gc2_207 0 n4 ns207 0 -6.96933215857e-06
Gc2_208 0 n4 ns208 0 2.26960817067e-05
Gc2_209 0 n4 ns209 0 -5.59927614195e-05
Gc2_210 0 n4 ns210 0 2.13288228821e-05
Gc2_211 0 n4 ns211 0 0.000195784030628
Gc2_212 0 n4 ns212 0 0.000105848897187
Gc2_213 0 n4 ns213 0 0.000198108574165
Gc2_214 0 n4 ns214 0 -0.000571818091336
Gc2_215 0 n4 ns215 0 -3.81174393078e-06
Gc2_216 0 n4 ns216 0 -4.31097731754e-06
Gc2_217 0 n4 ns217 0 1.46974867513e-05
Gc2_218 0 n4 ns218 0 3.08628446477e-05
Gc2_219 0 n4 ns219 0 -1.56335283719e-07
Gc2_220 0 n4 ns220 0 5.91294155223e-07
Gc2_221 0 n4 ns221 0 -0.000134597684164
Gc2_222 0 n4 ns222 0 -0.00037146759784
Gc2_223 0 n4 ns223 0 -0.000137759266717
Gc2_224 0 n4 ns224 0 -3.02516193398e-05
Gc2_225 0 n4 ns225 0 2.26659283033e-06
Gc2_226 0 n4 ns226 0 -1.1517448864e-06
Gc2_227 0 n4 ns227 0 -9.50029034427e-05
Gc2_228 0 n4 ns228 0 1.65048267641e-05
Gc2_229 0 n4 ns229 0 9.0731882255e-05
Gc2_230 0 n4 ns230 0 0.000155769658846
Gc2_231 0 n4 ns231 0 -0.000140346175163
Gc2_232 0 n4 ns232 0 -0.000603079489627
Gc2_233 0 n4 ns233 0 -2.9944820982e-05
Gc2_234 0 n4 ns234 0 -1.77230963969e-05
Gc2_235 0 n4 ns235 0 -0.0190704778863
Gc2_236 0 n4 ns236 0 0.00960552310185
Gc2_237 0 n4 ns237 0 0.00744764694235
Gc2_238 0 n4 ns238 0 0.0107542299807
Gc2_239 0 n4 ns239 0 -0.0130225062281
Gc2_240 0 n4 ns240 0 0.000100289031527
Gc2_241 0 n4 ns241 0 -2.15680692847e-05
Gc2_242 0 n4 ns242 0 7.92125056988e-06
Gc2_243 0 n4 ns243 0 -2.24189544418e-07
Gc2_244 0 n4 ns244 0 -3.06684945073e-07
Gc2_245 0 n4 ns245 0 4.51169277862e-06
Gc2_246 0 n4 ns246 0 -1.42817279298e-05
Gc2_247 0 n4 ns247 0 0.0002304274819
Gc2_248 0 n4 ns248 0 -0.000680579671757
Gc2_249 0 n4 ns249 0 -1.00097048955e-06
Gc2_250 0 n4 ns250 0 -1.9538266331e-07
Gc2_251 0 n4 ns251 0 0.00156949026933
Gc2_252 0 n4 ns252 0 0.00173747334121
Gc2_253 0 n4 ns253 0 -6.83888169538e-06
Gc2_254 0 n4 ns254 0 -2.20060786214e-05
Gc2_255 0 n4 ns255 0 -0.000299141217824
Gc2_256 0 n4 ns256 0 4.64550157678e-05
Gc2_257 0 n4 ns257 0 -0.0019798339774
Gc2_258 0 n4 ns258 0 -0.00119988168927
Gc2_259 0 n4 ns259 0 -0.00432939011312
Gc2_260 0 n4 ns260 0 0.00128542999416
Gc2_261 0 n4 ns261 0 4.25028489682e-05
Gc2_262 0 n4 ns262 0 4.50916930662e-05
Gc2_263 0 n4 ns263 0 -1.03655957945e-05
Gc2_264 0 n4 ns264 0 -5.72804263115e-06
Gc2_265 0 n4 ns265 0 4.84384662854e-06
Gc2_266 0 n4 ns266 0 -3.93284172647e-05
Gc2_267 0 n4 ns267 0 0.000142479726608
Gc2_268 0 n4 ns268 0 0.000219663265293
Gc2_269 0 n4 ns269 0 -9.39661395427e-05
Gc2_270 0 n4 ns270 0 -0.00145220597471
Gc2_271 0 n4 ns271 0 5.19167092962e-05
Gc2_272 0 n4 ns272 0 -4.6369793748e-05
Gc2_273 0 n4 ns273 0 -5.99202637093e-06
Gc2_274 0 n4 ns274 0 1.20499398896e-05
Gc2_275 0 n4 ns275 0 -1.01478040114e-05
Gc2_276 0 n4 ns276 0 7.78340055842e-06
Gc2_277 0 n4 ns277 0 -1.03238535071e-05
Gc2_278 0 n4 ns278 0 2.74972244429e-05
Gc2_279 0 n4 ns279 0 -1.79329191107e-05
Gc2_280 0 n4 ns280 0 -1.04912289369e-05
Gc2_281 0 n4 ns281 0 1.26557466093e-05
Gc2_282 0 n4 ns282 0 2.00722178601e-05
Gc2_283 0 n4 ns283 0 1.35268744172e-05
Gc2_284 0 n4 ns284 0 -1.897724895e-05
Gc2_285 0 n4 ns285 0 -4.04212144838e-05
Gc2_286 0 n4 ns286 0 5.53840305945e-06
Gc2_287 0 n4 ns287 0 1.11790448156e-06
Gc2_288 0 n4 ns288 0 -2.41963649212e-07
Gc2_289 0 n4 ns289 0 1.44309706522e-05
Gc2_290 0 n4 ns290 0 -1.44947170244e-06
Gc2_291 0 n4 ns291 0 -1.33772146951e-06
Gc2_292 0 n4 ns292 0 -1.93176221287e-06
Gc2_293 0 n4 ns293 0 -5.05047282125e-07
Gc2_294 0 n4 ns294 0 -5.3192635427e-07
Gc2_295 0 n4 ns295 0 3.17439299165e-06
Gc2_296 0 n4 ns296 0 6.67423708826e-08
Gc2_297 0 n4 ns297 0 1.86261996877e-06
Gc2_298 0 n4 ns298 0 -3.6807489508e-07
Gc2_299 0 n4 ns299 0 3.5522192297e-07
Gc2_300 0 n4 ns300 0 -1.0334457167e-06
Gc2_301 0 n4 ns301 0 -0.000689753988045
Gc2_302 0 n4 ns302 0 0.00156820534813
Gc2_303 0 n4 ns303 0 -7.11970011382e-05
Gc2_304 0 n4 ns304 0 0.000188388061927
Gc2_305 0 n4 ns305 0 4.05537421468e-05
Gc2_306 0 n4 ns306 0 3.43434030177e-05
Gc2_307 0 n4 ns307 0 -4.39863671156e-05
Gc2_308 0 n4 ns308 0 -0.000100292953879
Gc2_309 0 n4 ns309 0 3.94682514974e-08
Gc2_310 0 n4 ns310 0 7.77539325672e-08
Gc2_311 0 n4 ns311 0 8.11739320854e-06
Gc2_312 0 n4 ns312 0 -2.2833267562e-05
Gc2_313 0 n4 ns313 0 2.42363961819e-05
Gc2_314 0 n4 ns314 0 5.58173369249e-05
Gc2_315 0 n4 ns315 0 4.55149733073e-05
Gc2_316 0 n4 ns316 0 -7.29155452167e-06
Gc2_317 0 n4 ns317 0 -0.000102507531063
Gc2_318 0 n4 ns318 0 0.000113002180005
Gc2_319 0 n4 ns319 0 -5.0874968824e-05
Gc2_320 0 n4 ns320 0 -6.20960279094e-05
Gc2_321 0 n4 ns321 0 -5.10625987511e-06
Gc2_322 0 n4 ns322 0 -4.29430261784e-06
Gc2_323 0 n4 ns323 0 0.000171774595992
Gc2_324 0 n4 ns324 0 -0.000224413561709
Gc2_325 0 n4 ns325 0 1.00563639104e-05
Gc2_326 0 n4 ns326 0 -1.05332854066e-06
Gc2_327 0 n4 ns327 0 8.87383362326e-05
Gc2_328 0 n4 ns328 0 7.51378356281e-05
Gc2_329 0 n4 ns329 0 -0.000674257615842
Gc2_330 0 n4 ns330 0 6.74861429817e-05
Gc2_331 0 n4 ns331 0 1.70631709718e-06
Gc2_332 0 n4 ns332 0 -2.19479269627e-06
Gc2_333 0 n4 ns333 0 -5.62560072329e-06
Gc2_334 0 n4 ns334 0 1.4159661456e-05
Gc2_335 0 n4 ns335 0 -0.000326935149277
Gc2_336 0 n4 ns336 0 -0.00029775544298
Gc2_337 0 n4 ns337 0 2.94074630758e-05
Gc2_338 0 n4 ns338 0 -6.18019981081e-06
Gc2_339 0 n4 ns339 0 -2.10312776393e-05
Gc2_340 0 n4 ns340 0 0.000105158766262
Gc2_341 0 n4 ns341 0 0.000230177215451
Gc2_342 0 n4 ns342 0 0.000873311016669
Gc2_343 0 n4 ns343 0 -0.000117220972918
Gc2_344 0 n4 ns344 0 -2.84398029658e-05
Gc2_345 0 n4 ns345 0 1.01462259723e-05
Gc2_346 0 n4 ns346 0 -7.95218548908e-07
Gc2_347 0 n4 ns347 0 -0.000228935808033
Gc2_348 0 n4 ns348 0 8.10525466909e-05
Gc2_349 0 n4 ns349 0 -5.05598021148e-05
Gc2_350 0 n4 ns350 0 7.83263508378e-05
Gc2_351 0 n4 ns351 0 -0.000192327483417
Gc2_352 0 n4 ns352 0 -7.05541371546e-05
Gc2_353 0 n4 ns353 0 -6.82018633904e-05
Gc2_354 0 n4 ns354 0 -9.5433941995e-05
Gc2_355 0 n4 ns355 0 0.00051383883032
Gc2_356 0 n4 ns356 0 0.000420225312961
Gc2_357 0 n4 ns357 0 -5.66267715815e-05
Gc2_358 0 n4 ns358 0 6.0210081448e-06
Gc2_359 0 n4 ns359 0 2.18358158431e-05
Gc2_360 0 n4 ns360 0 -1.6230856179e-05
Gc2_361 0 n4 ns361 0 -0.000167627396284
Gc2_362 0 n4 ns362 0 -2.40415658014e-05
Gc2_363 0 n4 ns363 0 -0.000545578936078
Gc2_364 0 n4 ns364 0 0.00168026910686
Gc2_365 0 n4 ns365 0 -1.36510227317e-06
Gc2_366 0 n4 ns366 0 1.34306881875e-05
Gc2_367 0 n4 ns367 0 4.72797046276e-05
Gc2_368 0 n4 ns368 0 5.87764719346e-06
Gc2_369 0 n4 ns369 0 1.82304657145e-07
Gc2_370 0 n4 ns370 0 4.81733079973e-07
Gc2_371 0 n4 ns371 0 0.000228329019898
Gc2_372 0 n4 ns372 0 -0.000200838829807
Gc2_373 0 n4 ns373 0 0.000208903240727
Gc2_374 0 n4 ns374 0 -7.54488770504e-05
Gc2_375 0 n4 ns375 0 1.16650568288e-05
Gc2_376 0 n4 ns376 0 4.99297031003e-06
Gc2_377 0 n4 ns377 0 -0.000112602243097
Gc2_378 0 n4 ns378 0 3.57939487294e-06
Gc2_379 0 n4 ns379 0 -7.04052496235e-05
Gc2_380 0 n4 ns380 0 0.000176712461638
Gc2_381 0 n4 ns381 0 0.00120878070601
Gc2_382 0 n4 ns382 0 0.00326387988433
Gc2_383 0 n4 ns383 0 4.46884193741e-05
Gc2_384 0 n4 ns384 0 -3.06823217987e-05
Gc2_385 0 n4 ns385 0 -0.0138104387325
Gc2_386 0 n4 ns386 0 -0.00232923282268
Gc2_387 0 n4 ns387 0 -0.00468649390204
Gc2_388 0 n4 ns388 0 0.00692399800359
Gc2_389 0 n4 ns389 0 -0.0105981861961
Gc2_390 0 n4 ns390 0 -2.22294200647e-05
Gc2_391 0 n4 ns391 0 4.47602086364e-05
Gc2_392 0 n4 ns392 0 1.55296732e-05
Gc2_393 0 n4 ns393 0 4.40182151647e-07
Gc2_394 0 n4 ns394 0 -1.45063134187e-07
Gc2_395 0 n4 ns395 0 2.11442191756e-06
Gc2_396 0 n4 ns396 0 6.94458014432e-06
Gc2_397 0 n4 ns397 0 0.000311408525714
Gc2_398 0 n4 ns398 0 -0.000578225683334
Gc2_399 0 n4 ns399 0 -8.18654552268e-08
Gc2_400 0 n4 ns400 0 -1.23109959306e-06
Gc2_401 0 n4 ns401 0 -0.0016266076065
Gc2_402 0 n4 ns402 0 -1.12205737884e-05
Gc2_403 0 n4 ns403 0 1.00371726398e-05
Gc2_404 0 n4 ns404 0 -6.13583557782e-07
Gc2_405 0 n4 ns405 0 -0.0002350471771
Gc2_406 0 n4 ns406 0 8.29355502437e-05
Gc2_407 0 n4 ns407 0 0.00688875905762
Gc2_408 0 n4 ns408 0 0.00150437227619
Gc2_409 0 n4 ns409 0 0.00453865764441
Gc2_410 0 n4 ns410 0 -0.00491720569732
Gc2_411 0 n4 ns411 0 -1.13808645461e-06
Gc2_412 0 n4 ns412 0 6.59556491949e-05
Gc2_413 0 n4 ns413 0 -1.35745652056e-05
Gc2_414 0 n4 ns414 0 -1.06814198561e-05
Gc2_415 0 n4 ns415 0 -1.2803724681e-05
Gc2_416 0 n4 ns416 0 -6.68146174463e-05
Gc2_417 0 n4 ns417 0 -0.000302082034419
Gc2_418 0 n4 ns418 0 -0.000173031351078
Gc2_419 0 n4 ns419 0 0.00109921138423
Gc2_420 0 n4 ns420 0 -0.00237156114089
Gc2_421 0 n4 ns421 0 -8.70196278492e-06
Gc2_422 0 n4 ns422 0 -5.60985180204e-05
Gc2_423 0 n4 ns423 0 6.83055069342e-06
Gc2_424 0 n4 ns424 0 -3.47935586785e-05
Gc2_425 0 n4 ns425 0 1.22713742841e-05
Gc2_426 0 n4 ns426 0 -2.20583818235e-05
Gc2_427 0 n4 ns427 0 2.94303347561e-07
Gc2_428 0 n4 ns428 0 -1.81609181019e-05
Gc2_429 0 n4 ns429 0 4.08239346972e-07
Gc2_430 0 n4 ns430 0 -2.16409901818e-05
Gc2_431 0 n4 ns431 0 -6.9253182017e-05
Gc2_432 0 n4 ns432 0 -6.44897983797e-06
Gc2_433 0 n4 ns433 0 4.10009013804e-07
Gc2_434 0 n4 ns434 0 3.20978019827e-06
Gc2_435 0 n4 ns435 0 2.86696203755e-05
Gc2_436 0 n4 ns436 0 -2.64863194519e-06
Gc2_437 0 n4 ns437 0 -5.15648574289e-07
Gc2_438 0 n4 ns438 0 -4.87660349001e-07
Gc2_439 0 n4 ns439 0 -8.08637572999e-07
Gc2_440 0 n4 ns440 0 1.47188248243e-05
Gc2_441 0 n4 ns441 0 -8.02436363664e-06
Gc2_442 0 n4 ns442 0 5.99658104897e-07
Gc2_443 0 n4 ns443 0 -1.87815497832e-06
Gc2_444 0 n4 ns444 0 8.58098969859e-07
Gc2_445 0 n4 ns445 0 -4.19932664169e-06
Gc2_446 0 n4 ns446 0 -3.49226647051e-06
Gc2_447 0 n4 ns447 0 3.62766392594e-06
Gc2_448 0 n4 ns448 0 6.97365203851e-07
Gc2_449 0 n4 ns449 0 -5.66888997093e-07
Gc2_450 0 n4 ns450 0 9.37154546478e-07
Gc2_451 0 n4 ns451 0 0.000834924686168
Gc2_452 0 n4 ns452 0 -0.0020902318862
Gc2_453 0 n4 ns453 0 0.000349063189957
Gc2_454 0 n4 ns454 0 -0.000373533954901
Gc2_455 0 n4 ns455 0 4.33153371894e-05
Gc2_456 0 n4 ns456 0 1.99621608807e-05
Gc2_457 0 n4 ns457 0 -6.248270184e-05
Gc2_458 0 n4 ns458 0 -1.96654061812e-05
Gc2_459 0 n4 ns459 0 9.28549372621e-08
Gc2_460 0 n4 ns460 0 6.8676162083e-09
Gc2_461 0 n4 ns461 0 6.7826294933e-05
Gc2_462 0 n4 ns462 0 9.37657058003e-05
Gc2_463 0 n4 ns463 0 6.40385782157e-05
Gc2_464 0 n4 ns464 0 7.64960802022e-06
Gc2_465 0 n4 ns465 0 8.88350268342e-05
Gc2_466 0 n4 ns466 0 -6.56957471903e-05
Gc2_467 0 n4 ns467 0 0.000237000794118
Gc2_468 0 n4 ns468 0 -0.000175413457627
Gc2_469 0 n4 ns469 0 4.21493308291e-05
Gc2_470 0 n4 ns470 0 -0.000185129627816
Gc2_471 0 n4 ns471 0 -2.38344808271e-05
Gc2_472 0 n4 ns472 0 -7.31948282215e-05
Gc2_473 0 n4 ns473 0 -8.51706368758e-05
Gc2_474 0 n4 ns474 0 8.01812519656e-05
Gc2_475 0 n4 ns475 0 1.97067598988e-05
Gc2_476 0 n4 ns476 0 -4.01309567064e-06
Gc2_477 0 n4 ns477 0 1.75510135582e-05
Gc2_478 0 n4 ns478 0 2.60528110659e-05
Gc2_479 0 n4 ns479 0 0.00011077753422
Gc2_480 0 n4 ns480 0 -8.82554031863e-05
Gc2_481 0 n4 ns481 0 4.43322714626e-06
Gc2_482 0 n4 ns482 0 -7.36283401913e-06
Gc2_483 0 n4 ns483 0 1.00995174129e-05
Gc2_484 0 n4 ns484 0 2.10615026696e-06
Gc2_485 0 n4 ns485 0 0.000169391225139
Gc2_486 0 n4 ns486 0 -0.000124608937129
Gc2_487 0 n4 ns487 0 -2.94152745564e-05
Gc2_488 0 n4 ns488 0 8.67411744102e-06
Gc2_489 0 n4 ns489 0 1.65677521981e-05
Gc2_490 0 n4 ns490 0 4.91898612067e-05
Gc2_491 0 n4 ns491 0 0.000498630685038
Gc2_492 0 n4 ns492 0 -0.000130982558808
Gc2_493 0 n4 ns493 0 -9.02818413905e-05
Gc2_494 0 n4 ns494 0 1.16084119228e-05
Gc2_495 0 n4 ns495 0 -2.0733411042e-06
Gc2_496 0 n4 ns496 0 1.05384979313e-05
Gc2_497 0 n4 ns497 0 4.7898006726e-05
Gc2_498 0 n4 ns498 0 3.19028675755e-05
Gc2_499 0 n4 ns499 0 4.04440689805e-05
Gc2_500 0 n4 ns500 0 -8.53061927738e-06
Gc2_501 0 n4 ns501 0 2.37144780784e-05
Gc2_502 0 n4 ns502 0 7.28463642155e-05
Gc2_503 0 n4 ns503 0 -7.6142711496e-06
Gc2_504 0 n4 ns504 0 -0.000120323390814
Gc2_505 0 n4 ns505 0 0.000264103099162
Gc2_506 0 n4 ns506 0 2.27039197566e-05
Gc2_507 0 n4 ns507 0 2.16949795656e-05
Gc2_508 0 n4 ns508 0 2.0035560928e-05
Gc2_509 0 n4 ns509 0 -1.7854855423e-05
Gc2_510 0 n4 ns510 0 4.44285771367e-05
Gc2_511 0 n4 ns511 0 0.000190590329258
Gc2_512 0 n4 ns512 0 -7.7657004797e-05
Gc2_513 0 n4 ns513 0 -0.000144138196131
Gc2_514 0 n4 ns514 0 -0.000674869571514
Gc2_515 0 n4 ns515 0 -1.0041545005e-05
Gc2_516 0 n4 ns516 0 2.7768413774e-06
Gc2_517 0 n4 ns517 0 1.18526765414e-05
Gc2_518 0 n4 ns518 0 1.60503622207e-05
Gc2_519 0 n4 ns519 0 -5.98635481255e-08
Gc2_520 0 n4 ns520 0 2.22783357976e-07
Gc2_521 0 n4 ns521 0 0.000298974330099
Gc2_522 0 n4 ns522 0 -0.000316467257764
Gc2_523 0 n4 ns523 0 -9.19535965246e-05
Gc2_524 0 n4 ns524 0 -0.000323553748174
Gc2_525 0 n4 ns525 0 1.36260184062e-05
Gc2_526 0 n4 ns526 0 -3.05110059163e-06
Gc2_527 0 n4 ns527 0 -1.42671217734e-05
Gc2_528 0 n4 ns528 0 2.67611174651e-05
Gc2_529 0 n4 ns529 0 0.000110476566028
Gc2_530 0 n4 ns530 0 2.08058238658e-05
Gc2_531 0 n4 ns531 0 -0.000366616640068
Gc2_532 0 n4 ns532 0 -0.00186872048249
Gc2_533 0 n4 ns533 0 -4.00028411391e-05
Gc2_534 0 n4 ns534 0 5.00545475562e-06
Gc2_535 0 n4 ns535 0 -0.0157380835976
Gc2_536 0 n4 ns536 0 0.0112867954778
Gc2_537 0 n4 ns537 0 0.00556316115931
Gc2_538 0 n4 ns538 0 0.00675272134455
Gc2_539 0 n4 ns539 0 -0.0134401792897
Gc2_540 0 n4 ns540 0 2.40199820088e-05
Gc2_541 0 n4 ns541 0 -2.7568458742e-05
Gc2_542 0 n4 ns542 0 1.35404844338e-05
Gc2_543 0 n4 ns543 0 -1.46092409438e-07
Gc2_544 0 n4 ns544 0 -1.31702515553e-07
Gc2_545 0 n4 ns545 0 -2.20211232651e-06
Gc2_546 0 n4 ns546 0 -1.53951435048e-05
Gc2_547 0 n4 ns547 0 0.000145643850306
Gc2_548 0 n4 ns548 0 -0.00110169837972
Gc2_549 0 n4 ns549 0 2.75039216408e-07
Gc2_550 0 n4 ns550 0 3.67337720283e-07
Gc2_551 0 n4 ns551 0 0.00204068946482
Gc2_552 0 n4 ns552 0 0.000563433294423
Gc2_553 0 n4 ns553 0 -5.32084409835e-07
Gc2_554 0 n4 ns554 0 2.61378192331e-06
Gc2_555 0 n4 ns555 0 -0.000308724307679
Gc2_556 0 n4 ns556 0 4.43845949466e-05
Gc2_557 0 n4 ns557 0 -0.00325269707417
Gc2_558 0 n4 ns558 0 -0.00160002861173
Gc2_559 0 n4 ns559 0 -0.00404396498647
Gc2_560 0 n4 ns560 0 0.00287916058144
Gc2_561 0 n4 ns561 0 7.52685934614e-05
Gc2_562 0 n4 ns562 0 2.07993385761e-05
Gc2_563 0 n4 ns563 0 -1.29775392673e-05
Gc2_564 0 n4 ns564 0 3.29715058669e-06
Gc2_565 0 n4 ns565 0 1.15956817219e-05
Gc2_566 0 n4 ns566 0 -2.624439414e-05
Gc2_567 0 n4 ns567 0 0.000186515161944
Gc2_568 0 n4 ns568 0 0.000290989371447
Gc2_569 0 n4 ns569 0 -0.00113652603912
Gc2_570 0 n4 ns570 0 -0.00211631589749
Gc2_571 0 n4 ns571 0 3.81577146684e-05
Gc2_572 0 n4 ns572 0 -6.79057001685e-05
Gc2_573 0 n4 ns573 0 -1.81243149743e-05
Gc2_574 0 n4 ns574 0 4.70499931594e-06
Gc2_575 0 n4 ns575 0 -1.91348036333e-05
Gc2_576 0 n4 ns576 0 6.37694137582e-06
Gc2_577 0 n4 ns577 0 -7.98798161749e-06
Gc2_578 0 n4 ns578 0 2.16686329186e-05
Gc2_579 0 n4 ns579 0 -1.64087847569e-05
Gc2_580 0 n4 ns580 0 -1.43449722228e-05
Gc2_581 0 n4 ns581 0 2.93491540289e-05
Gc2_582 0 n4 ns582 0 2.46538416275e-05
Gc2_583 0 n4 ns583 0 1.27214553264e-05
Gc2_584 0 n4 ns584 0 -1.88539643354e-05
Gc2_585 0 n4 ns585 0 -3.49862812947e-05
Gc2_586 0 n4 ns586 0 4.66472088395e-06
Gc2_587 0 n4 ns587 0 3.56739729115e-07
Gc2_588 0 n4 ns588 0 1.34526061761e-08
Gc2_589 0 n4 ns589 0 9.22271786103e-06
Gc2_590 0 n4 ns590 0 -6.5028335587e-06
Gc2_591 0 n4 ns591 0 -2.01444294551e-06
Gc2_592 0 n4 ns592 0 1.79647787062e-07
Gc2_593 0 n4 ns593 0 -3.84667470109e-07
Gc2_594 0 n4 ns594 0 -1.53555340367e-07
Gc2_595 0 n4 ns595 0 2.26377680908e-06
Gc2_596 0 n4 ns596 0 3.19953113135e-07
Gc2_597 0 n4 ns597 0 3.44553458771e-06
Gc2_598 0 n4 ns598 0 -9.00861994494e-09
Gc2_599 0 n4 ns599 0 8.11371024618e-07
Gc2_600 0 n4 ns600 0 -4.57194218773e-07
Gc2_601 0 n4 ns601 0 -0.000791358003629
Gc2_602 0 n4 ns602 0 -0.000269183276733
Gc2_603 0 n4 ns603 0 0.000294171991338
Gc2_604 0 n4 ns604 0 -0.000210130316467
Gc2_605 0 n4 ns605 0 0.000180969473016
Gc2_606 0 n4 ns606 0 0.000339598323236
Gc2_607 0 n4 ns607 0 -0.000170867691447
Gc2_608 0 n4 ns608 0 -0.000188723708232
Gc2_609 0 n4 ns609 0 4.95213310961e-08
Gc2_610 0 n4 ns610 0 2.59145042697e-08
Gc2_611 0 n4 ns611 0 2.79606484003e-06
Gc2_612 0 n4 ns612 0 -0.000291274590906
Gc2_613 0 n4 ns613 0 0.000120515070651
Gc2_614 0 n4 ns614 0 5.78748272934e-06
Gc2_615 0 n4 ns615 0 0.000140818820022
Gc2_616 0 n4 ns616 0 -0.000129556573435
Gc2_617 0 n4 ns617 0 1.63265869738e-05
Gc2_618 0 n4 ns618 0 0.000214224893295
Gc2_619 0 n4 ns619 0 -0.000343167520737
Gc2_620 0 n4 ns620 0 3.5599857147e-05
Gc2_621 0 n4 ns621 0 -4.31513919237e-05
Gc2_622 0 n4 ns622 0 7.52249737056e-05
Gc2_623 0 n4 ns623 0 8.99338998655e-05
Gc2_624 0 n4 ns624 0 -0.00075113075808
Gc2_625 0 n4 ns625 0 -1.16426514828e-07
Gc2_626 0 n4 ns626 0 -1.90033285935e-06
Gc2_627 0 n4 ns627 0 0.00016186658521
Gc2_628 0 n4 ns628 0 2.15547044796e-06
Gc2_629 0 n4 ns629 0 -0.000403024168992
Gc2_630 0 n4 ns630 0 0.000692514110321
Gc2_631 0 n4 ns631 0 2.63591675942e-06
Gc2_632 0 n4 ns632 0 1.12784229121e-06
Gc2_633 0 n4 ns633 0 9.0237225506e-07
Gc2_634 0 n4 ns634 0 1.48771674499e-05
Gc2_635 0 n4 ns635 0 -0.000605410935945
Gc2_636 0 n4 ns636 0 -0.000295759589644
Gc2_637 0 n4 ns637 0 2.86546492162e-05
Gc2_638 0 n4 ns638 0 2.21261954569e-07
Gc2_639 0 n4 ns639 0 1.43504490779e-05
Gc2_640 0 n4 ns640 0 6.35310871857e-05
Gc2_641 0 n4 ns641 0 0.0010141453863
Gc2_642 0 n4 ns642 0 0.000124965681781
Gc2_643 0 n4 ns643 0 -0.000138060410554
Gc2_644 0 n4 ns644 0 5.73014508786e-05
Gc2_645 0 n4 ns645 0 6.64164282835e-06
Gc2_646 0 n4 ns646 0 -4.48503539947e-06
Gc2_647 0 n4 ns647 0 -0.000138073294674
Gc2_648 0 n4 ns648 0 0.000163565054673
Gc2_649 0 n4 ns649 0 -2.9158816e-05
Gc2_650 0 n4 ns650 0 5.52077609294e-05
Gc2_651 0 n4 ns651 0 -0.000250967056572
Gc2_652 0 n4 ns652 0 -8.10419125162e-05
Gc2_653 0 n4 ns653 0 -0.00021642226495
Gc2_654 0 n4 ns654 0 -0.000215484517879
Gc2_655 0 n4 ns655 0 0.000311336185592
Gc2_656 0 n4 ns656 0 -0.000251521133811
Gc2_657 0 n4 ns657 0 3.02326158292e-06
Gc2_658 0 n4 ns658 0 2.13677180996e-05
Gc2_659 0 n4 ns659 0 1.2332437071e-05
Gc2_660 0 n4 ns660 0 3.06084688637e-07
Gc2_661 0 n4 ns661 0 -6.12909628461e-05
Gc2_662 0 n4 ns662 0 -1.47944209629e-05
Gc2_663 0 n4 ns663 0 0.000115666880784
Gc2_664 0 n4 ns664 0 0.0012804419801
Gc2_665 0 n4 ns665 0 2.57552305465e-07
Gc2_666 0 n4 ns666 0 8.51678864709e-06
Gc2_667 0 n4 ns667 0 2.50879280905e-05
Gc2_668 0 n4 ns668 0 1.07460909834e-05
Gc2_669 0 n4 ns669 0 -1.34704082759e-07
Gc2_670 0 n4 ns670 0 2.13004758959e-07
Gc2_671 0 n4 ns671 0 0.000208001778645
Gc2_672 0 n4 ns672 0 -0.00055904810616
Gc2_673 0 n4 ns673 0 -0.00014387024226
Gc2_674 0 n4 ns674 0 -0.000331146703192
Gc2_675 0 n4 ns675 0 1.24663885152e-05
Gc2_676 0 n4 ns676 0 2.17084415685e-06
Gc2_677 0 n4 ns677 0 -1.56025852432e-05
Gc2_678 0 n4 ns678 0 -7.72817140422e-06
Gc2_679 0 n4 ns679 0 -4.35207815557e-05
Gc2_680 0 n4 ns680 0 2.71779773314e-05
Gc2_681 0 n4 ns681 0 0.00110193349152
Gc2_682 0 n4 ns682 0 0.00129979978269
Gc2_683 0 n4 ns683 0 2.78383866905e-05
Gc2_684 0 n4 ns684 0 -1.45073171851e-05
Gc2_685 0 n4 ns685 0 -0.0145001958546
Gc2_686 0 n4 ns686 0 0.00275676188157
Gc2_687 0 n4 ns687 0 -0.00315696048227
Gc2_688 0 n4 ns688 0 0.00277739473462
Gc2_689 0 n4 ns689 0 -0.0106995587738
Gc2_690 0 n4 ns690 0 3.56073577891e-06
Gc2_691 0 n4 ns691 0 2.83229887295e-05
Gc2_692 0 n4 ns692 0 1.59912045835e-05
Gc2_693 0 n4 ns693 0 1.87664318482e-07
Gc2_694 0 n4 ns694 0 -1.40433816916e-07
Gc2_695 0 n4 ns695 0 -8.46089552786e-07
Gc2_696 0 n4 ns696 0 7.25449064645e-06
Gc2_697 0 n4 ns697 0 4.49015491182e-05
Gc2_698 0 n4 ns698 0 -0.000442701868848
Gc2_699 0 n4 ns699 0 2.22217875755e-07
Gc2_700 0 n4 ns700 0 -1.53796235216e-06
Gc2_701 0 n4 ns701 0 -0.00174215894315
Gc2_702 0 n4 ns702 0 -0.000389113528277
Gc2_703 0 n4 ns703 0 1.85256560679e-05
Gc2_704 0 n4 ns704 0 6.83980226954e-06
Gc2_705 0 n4 ns705 0 -0.000208655939855
Gc2_706 0 n4 ns706 0 1.0912259759e-05
Gc2_707 0 n4 ns707 0 0.00322344770824
Gc2_708 0 n4 ns708 0 -0.00115190085505
Gc2_709 0 n4 ns709 0 -0.000252011491228
Gc2_710 0 n4 ns710 0 -0.00468645958131
Gc2_711 0 n4 ns711 0 -7.89564259377e-06
Gc2_712 0 n4 ns712 0 3.46823477064e-05
Gc2_713 0 n4 ns713 0 -1.25534034063e-05
Gc2_714 0 n4 ns714 0 -7.81608171424e-06
Gc2_715 0 n4 ns715 0 2.37093474221e-05
Gc2_716 0 n4 ns716 0 -5.52272836478e-05
Gc2_717 0 n4 ns717 0 -0.000152431514307
Gc2_718 0 n4 ns718 0 -0.000139877976628
Gc2_719 0 n4 ns719 0 0.000333380636412
Gc2_720 0 n4 ns720 0 -0.00216097073315
Gc2_721 0 n4 ns721 0 -1.37212882899e-05
Gc2_722 0 n4 ns722 0 -6.77359157635e-05
Gc2_723 0 n4 ns723 0 8.45772500813e-06
Gc2_724 0 n4 ns724 0 -2.32661294977e-05
Gc2_725 0 n4 ns725 0 1.26563187367e-05
Gc2_726 0 n4 ns726 0 -1.17145750135e-05
Gc2_727 0 n4 ns727 0 1.87461913207e-06
Gc2_728 0 n4 ns728 0 -1.62275026516e-05
Gc2_729 0 n4 ns729 0 4.32818697243e-06
Gc2_730 0 n4 ns730 0 -1.94327533136e-05
Gc2_731 0 n4 ns731 0 -5.76873018464e-05
Gc2_732 0 n4 ns732 0 -2.93392009897e-05
Gc2_733 0 n4 ns733 0 -2.76395446622e-06
Gc2_734 0 n4 ns734 0 3.06923939624e-06
Gc2_735 0 n4 ns735 0 2.37193961493e-05
Gc2_736 0 n4 ns736 0 4.41292799133e-06
Gc2_737 0 n4 ns737 0 -4.23702943999e-07
Gc2_738 0 n4 ns738 0 -2.30831126047e-07
Gc2_739 0 n4 ns739 0 6.75040967013e-06
Gc2_740 0 n4 ns740 0 2.40616929519e-05
Gc2_741 0 n4 ns741 0 -5.7070828135e-06
Gc2_742 0 n4 ns742 0 1.3978943337e-06
Gc2_743 0 n4 ns743 0 -1.26140785106e-06
Gc2_744 0 n4 ns744 0 7.02860222619e-07
Gc2_745 0 n4 ns745 0 -2.69079627489e-06
Gc2_746 0 n4 ns746 0 -1.86696651157e-06
Gc2_747 0 n4 ns747 0 4.30940236144e-06
Gc2_748 0 n4 ns748 0 -1.59361370787e-06
Gc2_749 0 n4 ns749 0 -6.80128933334e-07
Gc2_750 0 n4 ns750 0 -6.7512014466e-07
Gc2_751 0 n4 ns751 0 -0.000203656646478
Gc2_752 0 n4 ns752 0 0.000604232433607
Gc2_753 0 n4 ns753 0 -0.000136379224191
Gc2_754 0 n4 ns754 0 -0.000319484219292
Gc2_755 0 n4 ns755 0 5.2243686624e-05
Gc2_756 0 n4 ns756 0 -5.70555730393e-05
Gc2_757 0 n4 ns757 0 2.65720849341e-07
Gc2_758 0 n4 ns758 0 -6.6586219576e-05
Gc2_759 0 n4 ns759 0 4.14294610236e-08
Gc2_760 0 n4 ns760 0 -8.67494595284e-10
Gc2_761 0 n4 ns761 0 5.51359046916e-05
Gc2_762 0 n4 ns762 0 8.33733114384e-05
Gc2_763 0 n4 ns763 0 -4.56392475653e-06
Gc2_764 0 n4 ns764 0 -3.37159268206e-05
Gc2_765 0 n4 ns765 0 2.15277516833e-05
Gc2_766 0 n4 ns766 0 -1.62732584937e-06
Gc2_767 0 n4 ns767 0 5.90328611385e-05
Gc2_768 0 n4 ns768 0 -8.38200731719e-05
Gc2_769 0 n4 ns769 0 -8.46716583671e-05
Gc2_770 0 n4 ns770 0 -0.000176188199649
Gc2_771 0 n4 ns771 0 -3.86873356631e-05
Gc2_772 0 n4 ns772 0 -5.34366864878e-05
Gc2_773 0 n4 ns773 0 -0.000235849139112
Gc2_774 0 n4 ns774 0 0.000433184556902
Gc2_775 0 n4 ns775 0 1.93687490997e-05
Gc2_776 0 n4 ns776 0 -8.63554113117e-06
Gc2_777 0 n4 ns777 0 1.68917725553e-05
Gc2_778 0 n4 ns778 0 -9.76875219543e-06
Gc2_779 0 n4 ns779 0 2.11866753878e-05
Gc2_780 0 n4 ns780 0 0.000471316043473
Gc2_781 0 n4 ns781 0 -2.4163889249e-06
Gc2_782 0 n4 ns782 0 -5.58131624678e-06
Gc2_783 0 n4 ns783 0 1.13380675521e-05
Gc2_784 0 n4 ns784 0 1.31970982108e-06
Gc2_785 0 n4 ns785 0 0.000467153824907
Gc2_786 0 n4 ns786 0 -0.000103998237873
Gc2_787 0 n4 ns787 0 -2.89295370908e-05
Gc2_788 0 n4 ns788 0 4.25826018008e-06
Gc2_789 0 n4 ns789 0 -3.86486855946e-05
Gc2_790 0 n4 ns790 0 0.000118254817241
Gc2_791 0 n4 ns791 0 0.000795876994349
Gc2_792 0 n4 ns792 0 -0.000250020866219
Gc2_793 0 n4 ns793 0 -0.000155036251687
Gc2_794 0 n4 ns794 0 -6.84949639021e-06
Gc2_795 0 n4 ns795 0 6.2001062982e-06
Gc2_796 0 n4 ns796 0 -2.99265435955e-06
Gc2_797 0 n4 ns797 0 2.21274685805e-05
Gc2_798 0 n4 ns798 0 0.000116301775065
Gc2_799 0 n4 ns799 0 4.06627368265e-05
Gc2_800 0 n4 ns800 0 -6.24276306123e-06
Gc2_801 0 n4 ns801 0 8.34515806691e-05
Gc2_802 0 n4 ns802 0 4.83057151653e-05
Gc2_803 0 n4 ns803 0 8.18946891907e-05
Gc2_804 0 n4 ns804 0 -0.000103819120445
Gc2_805 0 n4 ns805 0 0.000260483222727
Gc2_806 0 n4 ns806 0 0.000263999675347
Gc2_807 0 n4 ns807 0 7.01079205294e-06
Gc2_808 0 n4 ns808 0 7.63385767949e-06
Gc2_809 0 n4 ns809 0 -2.25802768398e-05
Gc2_810 0 n4 ns810 0 4.84686239314e-05
Gc2_811 0 n4 ns811 0 0.000200750119212
Gc2_812 0 n4 ns812 0 -8.14754212264e-05
Gc2_813 0 n4 ns813 0 0.000406308998345
Gc2_814 0 n4 ns814 0 -0.000261781222137
Gc2_815 0 n4 ns815 0 -1.91209772021e-06
Gc2_816 0 n4 ns816 0 9.08741956845e-06
Gc2_817 0 n4 ns817 0 3.05585621083e-05
Gc2_818 0 n4 ns818 0 1.91381238679e-05
Gc2_819 0 n4 ns819 0 9.6624704416e-08
Gc2_820 0 n4 ns820 0 6.61279156807e-07
Gc2_821 0 n4 ns821 0 0.000347780985246
Gc2_822 0 n4 ns822 0 -8.1592997219e-05
Gc2_823 0 n4 ns823 0 0.000203334201752
Gc2_824 0 n4 ns824 0 -0.000162620422336
Gc2_825 0 n4 ns825 0 8.83546295525e-06
Gc2_826 0 n4 ns826 0 -5.01953607622e-06
Gc2_827 0 n4 ns827 0 -2.75481725184e-05
Gc2_828 0 n4 ns828 0 9.84943561349e-05
Gc2_829 0 n4 ns829 0 0.000197282626453
Gc2_830 0 n4 ns830 0 2.20468063178e-05
Gc2_831 0 n4 ns831 0 -0.000103761673356
Gc2_832 0 n4 ns832 0 -0.00205347595578
Gc2_833 0 n4 ns833 0 -4.20930433515e-05
Gc2_834 0 n4 ns834 0 5.48527881958e-06
Gc2_835 0 n4 ns835 0 -0.00205232628825
Gc2_836 0 n4 ns836 0 0.00642368476922
Gc2_837 0 n4 ns837 0 0.00242248053247
Gc2_838 0 n4 ns838 0 -0.000231879449808
Gc2_839 0 n4 ns839 0 -0.00655546536745
Gc2_840 0 n4 ns840 0 2.20965772113e-08
Gc2_841 0 n4 ns841 0 -2.38375836057e-05
Gc2_842 0 n4 ns842 0 1.2559691465e-05
Gc2_843 0 n4 ns843 0 -2.75505183228e-07
Gc2_844 0 n4 ns844 0 -4.89446231252e-08
Gc2_845 0 n4 ns845 0 -5.79170121308e-06
Gc2_846 0 n4 ns846 0 -1.10223619006e-05
Gc2_847 0 n4 ns847 0 -0.000258253419442
Gc2_848 0 n4 ns848 0 -0.00104102974891
Gc2_849 0 n4 ns849 0 2.03022556351e-08
Gc2_850 0 n4 ns850 0 -4.41820103002e-07
Gc2_851 0 n4 ns851 0 0.00206556628118
Gc2_852 0 n4 ns852 0 -0.000941719512232
Gc2_853 0 n4 ns853 0 -9.36716863462e-06
Gc2_854 0 n4 ns854 0 2.81489525282e-05
Gc2_855 0 n4 ns855 0 -0.000288397556908
Gc2_856 0 n4 ns856 0 0.000104952776609
Gc2_857 0 n4 ns857 0 -0.0023299988045
Gc2_858 0 n4 ns858 0 -0.000512454884753
Gc2_859 0 n4 ns859 0 0.000158275624656
Gc2_860 0 n4 ns860 0 0.00445117537424
Gc2_861 0 n4 ns861 0 8.16725892602e-05
Gc2_862 0 n4 ns862 0 1.44847264931e-05
Gc2_863 0 n4 ns863 0 -1.51327386564e-05
Gc2_864 0 n4 ns864 0 1.16247560063e-06
Gc2_865 0 n4 ns865 0 -1.15673805336e-05
Gc2_866 0 n4 ns866 0 -3.09085325735e-05
Gc2_867 0 n4 ns867 0 0.000154034763301
Gc2_868 0 n4 ns868 0 0.000313674498624
Gc2_869 0 n4 ns869 0 -0.00186828825764
Gc2_870 0 n4 ns870 0 -0.000743197649191
Gc2_871 0 n4 ns871 0 4.47897400246e-05
Gc2_872 0 n4 ns872 0 -5.86797227402e-05
Gc2_873 0 n4 ns873 0 -2.38504523904e-05
Gc2_874 0 n4 ns874 0 -4.92103954045e-06
Gc2_875 0 n4 ns875 0 -2.59470412754e-05
Gc2_876 0 n4 ns876 0 1.47643586629e-06
Gc2_877 0 n4 ns877 0 -4.054941017e-06
Gc2_878 0 n4 ns878 0 1.66064271087e-05
Gc2_879 0 n4 ns879 0 -7.09680519169e-06
Gc2_880 0 n4 ns880 0 -1.87130514759e-05
Gc2_881 0 n4 ns881 0 6.42515597037e-05
Gc2_882 0 n4 ns882 0 2.3196485176e-05
Gc2_883 0 n4 ns883 0 1.73456789631e-05
Gc2_884 0 n4 ns884 0 -1.34089682167e-05
Gc2_885 0 n4 ns885 0 -2.78034895631e-05
Gc2_886 0 n4 ns886 0 3.59862832963e-06
Gc2_887 0 n4 ns887 0 -2.63653747538e-07
Gc2_888 0 n4 ns888 0 -1.72213276981e-07
Gc2_889 0 n4 ns889 0 -2.84068239718e-05
Gc2_890 0 n4 ns890 0 -3.11189510012e-05
Gc2_891 0 n4 ns891 0 -3.47583578106e-06
Gc2_892 0 n4 ns892 0 7.91618722537e-08
Gc2_893 0 n4 ns893 0 -6.39593269777e-07
Gc2_894 0 n4 ns894 0 2.03530066986e-07
Gc2_895 0 n4 ns895 0 9.56713482467e-07
Gc2_896 0 n4 ns896 0 -2.24985832617e-06
Gc2_897 0 n4 ns897 0 2.43529547659e-06
Gc2_898 0 n4 ns898 0 4.84936884304e-06
Gc2_899 0 n4 ns899 0 2.398225004e-06
Gc2_900 0 n4 ns900 0 1.83837467753e-06
Gd2_1 0 n4 ni1 0 0.000144410145072
Gd2_2 0 n4 ni2 0 -0.0063816368713
Gd2_3 0 n4 ni3 0 6.40134574296e-06
Gd2_4 0 n4 ni4 0 0.00186470360157
Gd2_5 0 n4 ni5 0 -0.00031451540756
Gd2_6 0 n4 ni6 0 0.000624662234596
Gc3_1 0 n6 ns1 0 0.000996352839775
Gc3_2 0 n6 ns2 0 -0.00169052773173
Gc3_3 0 n6 ns3 0 0.000589015291072
Gc3_4 0 n6 ns4 0 8.70603361974e-06
Gc3_5 0 n6 ns5 0 -6.45587567334e-05
Gc3_6 0 n6 ns6 0 4.16577641967e-05
Gc3_7 0 n6 ns7 0 9.32203147209e-05
Gc3_8 0 n6 ns8 0 -7.5666347253e-06
Gc3_9 0 n6 ns9 0 -8.85110962737e-09
Gc3_10 0 n6 ns10 0 7.71233547654e-08
Gc3_11 0 n6 ns11 0 1.5832338993e-05
Gc3_12 0 n6 ns12 0 6.98736270824e-05
Gc3_13 0 n6 ns13 0 2.80398292895e-05
Gc3_14 0 n6 ns14 0 -6.46805293938e-06
Gc3_15 0 n6 ns15 0 5.97576671634e-05
Gc3_16 0 n6 ns16 0 -0.000105289865625
Gc3_17 0 n6 ns17 0 3.41195398413e-05
Gc3_18 0 n6 ns18 0 9.24808807983e-05
Gc3_19 0 n6 ns19 0 -3.81723221127e-05
Gc3_20 0 n6 ns20 0 2.08147916217e-05
Gc3_21 0 n6 ns21 0 0.000138753011704
Gc3_22 0 n6 ns22 0 -0.00014920862549
Gc3_23 0 n6 ns23 0 7.86669648797e-05
Gc3_24 0 n6 ns24 0 0.000179570357724
Gc3_25 0 n6 ns25 0 1.14912379545e-06
Gc3_26 0 n6 ns26 0 -8.49012808765e-07
Gc3_27 0 n6 ns27 0 0.00014595007703
Gc3_28 0 n6 ns28 0 -0.000136764699622
Gc3_29 0 n6 ns29 0 0.000300356275976
Gc3_30 0 n6 ns30 0 -0.000234780380318
Gc3_31 0 n6 ns31 0 3.9507946325e-06
Gc3_32 0 n6 ns32 0 1.03337295507e-07
Gc3_33 0 n6 ns33 0 -6.3058128783e-06
Gc3_34 0 n6 ns34 0 -6.17579391416e-06
Gc3_35 0 n6 ns35 0 -8.63589608619e-05
Gc3_36 0 n6 ns36 0 -0.000459188201823
Gc3_37 0 n6 ns37 0 3.9551355911e-05
Gc3_38 0 n6 ns38 0 3.04070263479e-05
Gc3_39 0 n6 ns39 0 -0.00011132195689
Gc3_40 0 n6 ns40 0 1.75973309496e-05
Gc3_41 0 n6 ns41 0 0.000177006018275
Gc3_42 0 n6 ns42 0 -0.000254688416919
Gc3_43 0 n6 ns43 0 1.26962425184e-05
Gc3_44 0 n6 ns44 0 5.65232446573e-05
Gc3_45 0 n6 ns45 0 -4.02256920003e-07
Gc3_46 0 n6 ns46 0 -3.07320807037e-05
Gc3_47 0 n6 ns47 0 -2.07262905508e-06
Gc3_48 0 n6 ns48 0 -0.000375794374354
Gc3_49 0 n6 ns49 0 -7.0632906778e-06
Gc3_50 0 n6 ns50 0 -1.24587925619e-05
Gc3_51 0 n6 ns51 0 -0.000118784589604
Gc3_52 0 n6 ns52 0 -8.93705048593e-06
Gc3_53 0 n6 ns53 0 -0.0002589419101
Gc3_54 0 n6 ns54 0 -6.97967422553e-05
Gc3_55 0 n6 ns55 0 0.000367741225211
Gc3_56 0 n6 ns56 0 -0.000177307892958
Gc3_57 0 n6 ns57 0 8.25554880056e-05
Gc3_58 0 n6 ns58 0 -3.15353382583e-05
Gc3_59 0 n6 ns59 0 -2.98202543438e-05
Gc3_60 0 n6 ns60 0 -1.24142138434e-05
Gc3_61 0 n6 ns61 0 5.62645874242e-05
Gc3_62 0 n6 ns62 0 0.000138169172625
Gc3_63 0 n6 ns63 0 -0.000468916400114
Gc3_64 0 n6 ns64 0 -0.00113404130185
Gc3_65 0 n6 ns65 0 5.22100564203e-06
Gc3_66 0 n6 ns66 0 -7.26231935099e-06
Gc3_67 0 n6 ns67 0 5.47668411889e-05
Gc3_68 0 n6 ns68 0 -0.000127907569308
Gc3_69 0 n6 ns69 0 1.57498821895e-06
Gc3_70 0 n6 ns70 0 6.02326968328e-08
Gc3_71 0 n6 ns71 0 -0.000682884544304
Gc3_72 0 n6 ns72 0 -0.000438505203209
Gc3_73 0 n6 ns73 0 -0.000245392275151
Gc3_74 0 n6 ns74 0 0.000146283470799
Gc3_75 0 n6 ns75 0 8.28392423857e-06
Gc3_76 0 n6 ns76 0 2.70564300883e-06
Gc3_77 0 n6 ns77 0 1.83113898758e-05
Gc3_78 0 n6 ns78 0 -7.21739256558e-06
Gc3_79 0 n6 ns79 0 7.29339476602e-05
Gc3_80 0 n6 ns80 0 -7.26824236444e-05
Gc3_81 0 n6 ns81 0 -6.73245196711e-05
Gc3_82 0 n6 ns82 0 -0.000172343459247
Gc3_83 0 n6 ns83 0 -1.68116387187e-05
Gc3_84 0 n6 ns84 0 4.74984833669e-05
Gc3_85 0 n6 ns85 0 -0.0120355203687
Gc3_86 0 n6 ns86 0 0.00959744631097
Gc3_87 0 n6 ns87 0 0.00483296969935
Gc3_88 0 n6 ns88 0 0.00313689709544
Gc3_89 0 n6 ns89 0 -0.0112468250686
Gc3_90 0 n6 ns90 0 2.44291841847e-05
Gc3_91 0 n6 ns91 0 -2.82309444976e-05
Gc3_92 0 n6 ns92 0 -1.45784351848e-05
Gc3_93 0 n6 ns93 0 1.65497678656e-08
Gc3_94 0 n6 ns94 0 -1.80154483018e-08
Gc3_95 0 n6 ns95 0 -9.70292304808e-06
Gc3_96 0 n6 ns96 0 -6.59271090763e-06
Gc3_97 0 n6 ns97 0 0.000244303694825
Gc3_98 0 n6 ns98 0 -0.00149580578352
Gc3_99 0 n6 ns99 0 7.75852536346e-07
Gc3_100 0 n6 ns100 0 2.39318944994e-06
Gc3_101 0 n6 ns101 0 0.0021213517642
Gc3_102 0 n6 ns102 0 -0.000632794033453
Gc3_103 0 n6 ns103 0 1.03688465388e-06
Gc3_104 0 n6 ns104 0 3.14749727653e-05
Gc3_105 0 n6 ns105 0 -0.000250952363096
Gc3_106 0 n6 ns106 0 0.00017084661164
Gc3_107 0 n6 ns107 0 -0.00274234564165
Gc3_108 0 n6 ns108 0 -0.000284586770458
Gc3_109 0 n6 ns109 0 -0.00315201358042
Gc3_110 0 n6 ns110 0 0.00441684124708
Gc3_111 0 n6 ns111 0 -4.06570287367e-05
Gc3_112 0 n6 ns112 0 -3.46657996286e-05
Gc3_113 0 n6 ns113 0 -9.0751943787e-06
Gc3_114 0 n6 ns114 0 -2.24816196186e-06
Gc3_115 0 n6 ns115 0 -3.04769248157e-05
Gc3_116 0 n6 ns116 0 -2.88986617855e-05
Gc3_117 0 n6 ns117 0 7.18026944601e-05
Gc3_118 0 n6 ns118 0 -4.11625610831e-05
Gc3_119 0 n6 ns119 0 -0.00139749400954
Gc3_120 0 n6 ns120 0 -0.0025009939042
Gc3_121 0 n6 ns121 0 -2.61303089281e-05
Gc3_122 0 n6 ns122 0 4.6403977828e-05
Gc3_123 0 n6 ns123 0 2.8041034761e-05
Gc3_124 0 n6 ns124 0 -2.97677582669e-05
Gc3_125 0 n6 ns125 0 1.11121799705e-05
Gc3_126 0 n6 ns126 0 1.26078431684e-05
Gc3_127 0 n6 ns127 0 1.82953569302e-05
Gc3_128 0 n6 ns128 0 1.55261279523e-05
Gc3_129 0 n6 ns129 0 4.63705868217e-05
Gc3_130 0 n6 ns130 0 8.64914810756e-06
Gc3_131 0 n6 ns131 0 3.59877612354e-05
Gc3_132 0 n6 ns132 0 -1.6364277714e-05
Gc3_133 0 n6 ns133 0 1.11422916939e-05
Gc3_134 0 n6 ns134 0 -7.77144211131e-06
Gc3_135 0 n6 ns135 0 -1.60494640322e-05
Gc3_136 0 n6 ns136 0 2.78370314842e-05
Gc3_137 0 n6 ns137 0 -3.92525965732e-07
Gc3_138 0 n6 ns138 0 -9.36423582445e-07
Gc3_139 0 n6 ns139 0 3.70545330163e-05
Gc3_140 0 n6 ns140 0 -1.05027962133e-05
Gc3_141 0 n6 ns141 0 3.89487100927e-08
Gc3_142 0 n6 ns142 0 2.32948708856e-06
Gc3_143 0 n6 ns143 0 2.86686832501e-07
Gc3_144 0 n6 ns144 0 7.78133965296e-07
Gc3_145 0 n6 ns145 0 -2.37719942945e-07
Gc3_146 0 n6 ns146 0 2.22717012112e-06
Gc3_147 0 n6 ns147 0 4.18501043695e-07
Gc3_148 0 n6 ns148 0 -3.23781174662e-06
Gc3_149 0 n6 ns149 0 -8.63689197223e-07
Gc3_150 0 n6 ns150 0 -9.50711620636e-07
Gc3_151 0 n6 ns151 0 -0.000689753988045
Gc3_152 0 n6 ns152 0 0.00156820534813
Gc3_153 0 n6 ns153 0 -7.11970011382e-05
Gc3_154 0 n6 ns154 0 0.000188388061927
Gc3_155 0 n6 ns155 0 4.05537421468e-05
Gc3_156 0 n6 ns156 0 3.43434030177e-05
Gc3_157 0 n6 ns157 0 -4.39863671156e-05
Gc3_158 0 n6 ns158 0 -0.000100292953879
Gc3_159 0 n6 ns159 0 3.94682514974e-08
Gc3_160 0 n6 ns160 0 7.77539325672e-08
Gc3_161 0 n6 ns161 0 8.11739320854e-06
Gc3_162 0 n6 ns162 0 -2.2833267562e-05
Gc3_163 0 n6 ns163 0 2.42363961819e-05
Gc3_164 0 n6 ns164 0 5.58173369249e-05
Gc3_165 0 n6 ns165 0 4.55149733073e-05
Gc3_166 0 n6 ns166 0 -7.29155452167e-06
Gc3_167 0 n6 ns167 0 -0.000102507531063
Gc3_168 0 n6 ns168 0 0.000113002180005
Gc3_169 0 n6 ns169 0 -5.0874968824e-05
Gc3_170 0 n6 ns170 0 -6.20960279094e-05
Gc3_171 0 n6 ns171 0 -5.10625987511e-06
Gc3_172 0 n6 ns172 0 -4.29430261784e-06
Gc3_173 0 n6 ns173 0 0.000171774595992
Gc3_174 0 n6 ns174 0 -0.000224413561709
Gc3_175 0 n6 ns175 0 1.00563639104e-05
Gc3_176 0 n6 ns176 0 -1.05332854066e-06
Gc3_177 0 n6 ns177 0 8.87383362326e-05
Gc3_178 0 n6 ns178 0 7.51378356281e-05
Gc3_179 0 n6 ns179 0 -0.000674257615842
Gc3_180 0 n6 ns180 0 6.74861429817e-05
Gc3_181 0 n6 ns181 0 1.70631709718e-06
Gc3_182 0 n6 ns182 0 -2.19479269627e-06
Gc3_183 0 n6 ns183 0 -5.62560072329e-06
Gc3_184 0 n6 ns184 0 1.4159661456e-05
Gc3_185 0 n6 ns185 0 -0.000326935149277
Gc3_186 0 n6 ns186 0 -0.00029775544298
Gc3_187 0 n6 ns187 0 2.94074630758e-05
Gc3_188 0 n6 ns188 0 -6.18019981081e-06
Gc3_189 0 n6 ns189 0 -2.10312776393e-05
Gc3_190 0 n6 ns190 0 0.000105158766262
Gc3_191 0 n6 ns191 0 0.000230177215451
Gc3_192 0 n6 ns192 0 0.000873311016669
Gc3_193 0 n6 ns193 0 -0.000117220972918
Gc3_194 0 n6 ns194 0 -2.84398029658e-05
Gc3_195 0 n6 ns195 0 1.01462259723e-05
Gc3_196 0 n6 ns196 0 -7.95218548908e-07
Gc3_197 0 n6 ns197 0 -0.000228935808033
Gc3_198 0 n6 ns198 0 8.10525466909e-05
Gc3_199 0 n6 ns199 0 -5.05598021148e-05
Gc3_200 0 n6 ns200 0 7.83263508378e-05
Gc3_201 0 n6 ns201 0 -0.000192327483417
Gc3_202 0 n6 ns202 0 -7.05541371546e-05
Gc3_203 0 n6 ns203 0 -6.82018633904e-05
Gc3_204 0 n6 ns204 0 -9.5433941995e-05
Gc3_205 0 n6 ns205 0 0.00051383883032
Gc3_206 0 n6 ns206 0 0.000420225312961
Gc3_207 0 n6 ns207 0 -5.66267715815e-05
Gc3_208 0 n6 ns208 0 6.0210081448e-06
Gc3_209 0 n6 ns209 0 2.18358158431e-05
Gc3_210 0 n6 ns210 0 -1.6230856179e-05
Gc3_211 0 n6 ns211 0 -0.000167627396284
Gc3_212 0 n6 ns212 0 -2.40415658014e-05
Gc3_213 0 n6 ns213 0 -0.000545578936078
Gc3_214 0 n6 ns214 0 0.00168026910686
Gc3_215 0 n6 ns215 0 -1.36510227317e-06
Gc3_216 0 n6 ns216 0 1.34306881875e-05
Gc3_217 0 n6 ns217 0 4.72797046276e-05
Gc3_218 0 n6 ns218 0 5.87764719346e-06
Gc3_219 0 n6 ns219 0 1.82304657145e-07
Gc3_220 0 n6 ns220 0 4.81733079973e-07
Gc3_221 0 n6 ns221 0 0.000228329019898
Gc3_222 0 n6 ns222 0 -0.000200838829807
Gc3_223 0 n6 ns223 0 0.000208903240727
Gc3_224 0 n6 ns224 0 -7.54488770504e-05
Gc3_225 0 n6 ns225 0 1.16650568288e-05
Gc3_226 0 n6 ns226 0 4.99297031003e-06
Gc3_227 0 n6 ns227 0 -0.000112602243097
Gc3_228 0 n6 ns228 0 3.57939487294e-06
Gc3_229 0 n6 ns229 0 -7.04052496235e-05
Gc3_230 0 n6 ns230 0 0.000176712461638
Gc3_231 0 n6 ns231 0 0.00120878070601
Gc3_232 0 n6 ns232 0 0.00326387988433
Gc3_233 0 n6 ns233 0 4.46884193741e-05
Gc3_234 0 n6 ns234 0 -3.06823217987e-05
Gc3_235 0 n6 ns235 0 -0.0138104387325
Gc3_236 0 n6 ns236 0 -0.00232923282268
Gc3_237 0 n6 ns237 0 -0.00468649390204
Gc3_238 0 n6 ns238 0 0.00692399800359
Gc3_239 0 n6 ns239 0 -0.0105981861961
Gc3_240 0 n6 ns240 0 -2.22294200647e-05
Gc3_241 0 n6 ns241 0 4.47602086364e-05
Gc3_242 0 n6 ns242 0 1.55296732e-05
Gc3_243 0 n6 ns243 0 4.40182151647e-07
Gc3_244 0 n6 ns244 0 -1.45063134187e-07
Gc3_245 0 n6 ns245 0 2.11442191756e-06
Gc3_246 0 n6 ns246 0 6.94458014432e-06
Gc3_247 0 n6 ns247 0 0.000311408525714
Gc3_248 0 n6 ns248 0 -0.000578225683334
Gc3_249 0 n6 ns249 0 -8.18654552268e-08
Gc3_250 0 n6 ns250 0 -1.23109959306e-06
Gc3_251 0 n6 ns251 0 -0.0016266076065
Gc3_252 0 n6 ns252 0 -1.12205737884e-05
Gc3_253 0 n6 ns253 0 1.00371726398e-05
Gc3_254 0 n6 ns254 0 -6.13583557782e-07
Gc3_255 0 n6 ns255 0 -0.0002350471771
Gc3_256 0 n6 ns256 0 8.29355502437e-05
Gc3_257 0 n6 ns257 0 0.00688875905762
Gc3_258 0 n6 ns258 0 0.00150437227619
Gc3_259 0 n6 ns259 0 0.00453865764441
Gc3_260 0 n6 ns260 0 -0.00491720569732
Gc3_261 0 n6 ns261 0 -1.13808645461e-06
Gc3_262 0 n6 ns262 0 6.59556491949e-05
Gc3_263 0 n6 ns263 0 -1.35745652056e-05
Gc3_264 0 n6 ns264 0 -1.06814198561e-05
Gc3_265 0 n6 ns265 0 -1.2803724681e-05
Gc3_266 0 n6 ns266 0 -6.68146174463e-05
Gc3_267 0 n6 ns267 0 -0.000302082034419
Gc3_268 0 n6 ns268 0 -0.000173031351078
Gc3_269 0 n6 ns269 0 0.00109921138423
Gc3_270 0 n6 ns270 0 -0.00237156114089
Gc3_271 0 n6 ns271 0 -8.70196278492e-06
Gc3_272 0 n6 ns272 0 -5.60985180204e-05
Gc3_273 0 n6 ns273 0 6.83055069342e-06
Gc3_274 0 n6 ns274 0 -3.47935586785e-05
Gc3_275 0 n6 ns275 0 1.22713742841e-05
Gc3_276 0 n6 ns276 0 -2.20583818235e-05
Gc3_277 0 n6 ns277 0 2.94303347561e-07
Gc3_278 0 n6 ns278 0 -1.81609181019e-05
Gc3_279 0 n6 ns279 0 4.08239346972e-07
Gc3_280 0 n6 ns280 0 -2.16409901818e-05
Gc3_281 0 n6 ns281 0 -6.9253182017e-05
Gc3_282 0 n6 ns282 0 -6.44897983797e-06
Gc3_283 0 n6 ns283 0 4.10009013804e-07
Gc3_284 0 n6 ns284 0 3.20978019827e-06
Gc3_285 0 n6 ns285 0 2.86696203755e-05
Gc3_286 0 n6 ns286 0 -2.64863194519e-06
Gc3_287 0 n6 ns287 0 -5.15648574289e-07
Gc3_288 0 n6 ns288 0 -4.87660349001e-07
Gc3_289 0 n6 ns289 0 -8.08637572999e-07
Gc3_290 0 n6 ns290 0 1.47188248243e-05
Gc3_291 0 n6 ns291 0 -8.02436363664e-06
Gc3_292 0 n6 ns292 0 5.99658104897e-07
Gc3_293 0 n6 ns293 0 -1.87815497832e-06
Gc3_294 0 n6 ns294 0 8.58098969859e-07
Gc3_295 0 n6 ns295 0 -4.19932664169e-06
Gc3_296 0 n6 ns296 0 -3.49226647051e-06
Gc3_297 0 n6 ns297 0 3.62766392594e-06
Gc3_298 0 n6 ns298 0 6.97365203851e-07
Gc3_299 0 n6 ns299 0 -5.66888997093e-07
Gc3_300 0 n6 ns300 0 9.37154546478e-07
Gc3_301 0 n6 ns301 0 -0.00611716698299
Gc3_302 0 n6 ns302 0 0.00374231041183
Gc3_303 0 n6 ns303 0 -0.000543443388758
Gc3_304 0 n6 ns304 0 -5.79623403614e-05
Gc3_305 0 n6 ns305 0 -1.76629022433e-05
Gc3_306 0 n6 ns306 0 1.71503108125e-05
Gc3_307 0 n6 ns307 0 0.000177495969987
Gc3_308 0 n6 ns308 0 -7.46192123462e-05
Gc3_309 0 n6 ns309 0 -4.00239659165e-08
Gc3_310 0 n6 ns310 0 -5.71286300841e-08
Gc3_311 0 n6 ns311 0 -9.75177814644e-05
Gc3_312 0 n6 ns312 0 1.50879980078e-05
Gc3_313 0 n6 ns313 0 1.65723654832e-05
Gc3_314 0 n6 ns314 0 -0.000105140380567
Gc3_315 0 n6 ns315 0 -7.71351113442e-05
Gc3_316 0 n6 ns316 0 -0.000138737652241
Gc3_317 0 n6 ns317 0 1.1755864809e-05
Gc3_318 0 n6 ns318 0 0.000153540479885
Gc3_319 0 n6 ns319 0 -0.000277344586368
Gc3_320 0 n6 ns320 0 -0.000137237547594
Gc3_321 0 n6 ns321 0 8.8593657764e-05
Gc3_322 0 n6 ns322 0 -3.67085186445e-05
Gc3_323 0 n6 ns323 0 -0.000195165640561
Gc3_324 0 n6 ns324 0 0.000366680936595
Gc3_325 0 n6 ns325 0 8.13774667666e-06
Gc3_326 0 n6 ns326 0 5.49434740459e-06
Gc3_327 0 n6 ns327 0 0.000107426720151
Gc3_328 0 n6 ns328 0 -3.76356964099e-05
Gc3_329 0 n6 ns329 0 0.000309952703189
Gc3_330 0 n6 ns330 0 -7.84068465347e-05
Gc3_331 0 n6 ns331 0 -9.75357757531e-07
Gc3_332 0 n6 ns332 0 -8.0236795339e-08
Gc3_333 0 n6 ns333 0 3.19036487118e-06
Gc3_334 0 n6 ns334 0 5.1805920183e-06
Gc3_335 0 n6 ns335 0 -0.000255785141406
Gc3_336 0 n6 ns336 0 -0.000450825868049
Gc3_337 0 n6 ns337 0 4.77763666637e-05
Gc3_338 0 n6 ns338 0 3.19755155015e-05
Gc3_339 0 n6 ns339 0 -0.000177559313167
Gc3_340 0 n6 ns340 0 -5.40686327942e-05
Gc3_341 0 n6 ns341 0 4.480690836e-05
Gc3_342 0 n6 ns342 0 0.000679034506727
Gc3_343 0 n6 ns343 0 6.3046916243e-05
Gc3_344 0 n6 ns344 0 -6.40187651609e-05
Gc3_345 0 n6 ns345 0 2.05107021431e-05
Gc3_346 0 n6 ns346 0 -2.21618546891e-05
Gc3_347 0 n6 ns347 0 9.20651907299e-05
Gc3_348 0 n6 ns348 0 -0.000442603427904
Gc3_349 0 n6 ns349 0 2.85438451969e-05
Gc3_350 0 n6 ns350 0 -1.23817220958e-05
Gc3_351 0 n6 ns351 0 -7.82662028714e-05
Gc3_352 0 n6 ns352 0 3.79125786952e-05
Gc3_353 0 n6 ns353 0 -0.000151327018706
Gc3_354 0 n6 ns354 0 5.26539845572e-05
Gc3_355 0 n6 ns355 0 3.59683159353e-05
Gc3_356 0 n6 ns356 0 7.56409926603e-05
Gc3_357 0 n6 ns357 0 6.91824105667e-05
Gc3_358 0 n6 ns358 0 -3.74307084311e-05
Gc3_359 0 n6 ns359 0 -4.4139253722e-05
Gc3_360 0 n6 ns360 0 -1.6710384489e-05
Gc3_361 0 n6 ns361 0 9.72201079907e-05
Gc3_362 0 n6 ns362 0 0.000189258990418
Gc3_363 0 n6 ns363 0 0.000612178265968
Gc3_364 0 n6 ns364 0 -0.00060310316163
Gc3_365 0 n6 ns365 0 9.48238787226e-06
Gc3_366 0 n6 ns366 0 7.30233912632e-06
Gc3_367 0 n6 ns367 0 3.94127190819e-05
Gc3_368 0 n6 ns368 0 -8.95855622392e-05
Gc3_369 0 n6 ns369 0 2.50778803869e-07
Gc3_370 0 n6 ns370 0 2.28398260135e-07
Gc3_371 0 n6 ns371 0 0.000432401611888
Gc3_372 0 n6 ns372 0 -0.000814748845339
Gc3_373 0 n6 ns373 0 -0.000189482933691
Gc3_374 0 n6 ns374 0 -0.000343085902587
Gc3_375 0 n6 ns375 0 2.59836250843e-05
Gc3_376 0 n6 ns376 0 -4.55753126381e-06
Gc3_377 0 n6 ns377 0 3.12521112469e-05
Gc3_378 0 n6 ns378 0 -1.74194911338e-05
Gc3_379 0 n6 ns379 0 8.34908368823e-05
Gc3_380 0 n6 ns380 0 -7.26575245488e-05
Gc3_381 0 n6 ns381 0 -0.0014964932376
Gc3_382 0 n6 ns382 0 -0.00148707187472
Gc3_383 0 n6 ns383 0 -2.73627762771e-05
Gc3_384 0 n6 ns384 0 5.10446631582e-05
Gc3_385 0 n6 ns385 0 -0.0157409273754
Gc3_386 0 n6 ns386 0 0.0109504223307
Gc3_387 0 n6 ns387 0 0.00778639808736
Gc3_388 0 n6 ns388 0 0.00846573090648
Gc3_389 0 n6 ns389 0 -0.0125774735051
Gc3_390 0 n6 ns390 0 0.000106335365251
Gc3_391 0 n6 ns391 0 -3.3568567051e-05
Gc3_392 0 n6 ns392 0 -3.16196196429e-05
Gc3_393 0 n6 ns393 0 -3.81941988132e-07
Gc3_394 0 n6 ns394 0 1.09987613209e-07
Gc3_395 0 n6 ns395 0 -8.26519488886e-06
Gc3_396 0 n6 ns396 0 -2.85278541232e-06
Gc3_397 0 n6 ns397 0 -0.000130652253796
Gc3_398 0 n6 ns398 0 -0.00122079135998
Gc3_399 0 n6 ns399 0 -2.25353775749e-08
Gc3_400 0 n6 ns400 0 1.63782929702e-06
Gc3_401 0 n6 ns401 0 0.001587463583
Gc3_402 0 n6 ns402 0 0.000354903104035
Gc3_403 0 n6 ns403 0 5.1290285667e-06
Gc3_404 0 n6 ns404 0 1.09442005615e-05
Gc3_405 0 n6 ns405 0 -0.000305361107068
Gc3_406 0 n6 ns406 0 0.000236849395042
Gc3_407 0 n6 ns407 0 -0.00336370910934
Gc3_408 0 n6 ns408 0 0.000704312867184
Gc3_409 0 n6 ns409 0 -0.00115040094815
Gc3_410 0 n6 ns410 0 0.00426181497586
Gc3_411 0 n6 ns411 0 -8.42046728676e-05
Gc3_412 0 n6 ns412 0 -2.95440351871e-05
Gc3_413 0 n6 ns413 0 -9.86730598243e-07
Gc3_414 0 n6 ns414 0 -7.02231083213e-06
Gc3_415 0 n6 ns415 0 -3.19656916827e-05
Gc3_416 0 n6 ns416 0 -4.43805732549e-05
Gc3_417 0 n6 ns417 0 0.000130336365245
Gc3_418 0 n6 ns418 0 -0.000119483059825
Gc3_419 0 n6 ns419 0 -0.00219798667652
Gc3_420 0 n6 ns420 0 -0.00148007212743
Gc3_421 0 n6 ns421 0 -2.88907532965e-05
Gc3_422 0 n6 ns422 0 6.72821697052e-05
Gc3_423 0 n6 ns423 0 4.20190493595e-05
Gc3_424 0 n6 ns424 0 -3.49382432847e-05
Gc3_425 0 n6 ns425 0 1.06282080085e-05
Gc3_426 0 n6 ns426 0 9.18472387252e-06
Gc3_427 0 n6 ns427 0 2.13982067971e-05
Gc3_428 0 n6 ns428 0 1.60972897065e-05
Gc3_429 0 n6 ns429 0 5.31135837858e-05
Gc3_430 0 n6 ns430 0 7.82254419102e-06
Gc3_431 0 n6 ns431 0 5.55180270432e-05
Gc3_432 0 n6 ns432 0 -4.72007279893e-06
Gc3_433 0 n6 ns433 0 1.45503018215e-05
Gc3_434 0 n6 ns434 0 -3.3184957969e-06
Gc3_435 0 n6 ns435 0 -1.57037176478e-05
Gc3_436 0 n6 ns436 0 2.72983798351e-05
Gc3_437 0 n6 ns437 0 -9.92714257283e-07
Gc3_438 0 n6 ns438 0 -2.20250931142e-06
Gc3_439 0 n6 ns439 0 2.30380810097e-05
Gc3_440 0 n6 ns440 0 -4.0669344053e-05
Gc3_441 0 n6 ns441 0 -4.84514084095e-07
Gc3_442 0 n6 ns442 0 -1.06099640898e-06
Gc3_443 0 n6 ns443 0 -6.4048476279e-07
Gc3_444 0 n6 ns444 0 2.44767573312e-07
Gc3_445 0 n6 ns445 0 9.97556775791e-07
Gc3_446 0 n6 ns446 0 -7.84874316434e-07
Gc3_447 0 n6 ns447 0 -3.16659069227e-06
Gc3_448 0 n6 ns448 0 -1.77564256911e-06
Gc3_449 0 n6 ns449 0 -6.35935765993e-07
Gc3_450 0 n6 ns450 0 1.0811704389e-06
Gc3_451 0 n6 ns451 0 -0.000774272420436
Gc3_452 0 n6 ns452 0 0.00228740227924
Gc3_453 0 n6 ns453 0 -0.00010794763119
Gc3_454 0 n6 ns454 0 -0.000496802561019
Gc3_455 0 n6 ns455 0 0.000441967324389
Gc3_456 0 n6 ns456 0 1.44660165528e-05
Gc3_457 0 n6 ns457 0 -0.000279023538044
Gc3_458 0 n6 ns458 0 -8.0787752245e-06
Gc3_459 0 n6 ns459 0 -2.85829892296e-10
Gc3_460 0 n6 ns460 0 -5.15811689053e-09
Gc3_461 0 n6 ns461 0 -0.000278166028605
Gc3_462 0 n6 ns462 0 -0.000131375190698
Gc3_463 0 n6 ns463 0 1.80146957382e-05
Gc3_464 0 n6 ns464 0 -0.000144259545312
Gc3_465 0 n6 ns465 0 3.53091797958e-05
Gc3_466 0 n6 ns466 0 -0.000213530765341
Gc3_467 0 n6 ns467 0 8.71788596346e-05
Gc3_468 0 n6 ns468 0 8.87836049251e-06
Gc3_469 0 n6 ns469 0 -0.000183452400417
Gc3_470 0 n6 ns470 0 0.000240944856112
Gc3_471 0 n6 ns471 0 6.04253598805e-06
Gc3_472 0 n6 ns472 0 0.000130076385193
Gc3_473 0 n6 ns473 0 -0.000723372891481
Gc3_474 0 n6 ns474 0 -0.000416774940558
Gc3_475 0 n6 ns475 0 1.19383731156e-06
Gc3_476 0 n6 ns476 0 1.59894293564e-05
Gc3_477 0 n6 ns477 0 0.000110216155831
Gc3_478 0 n6 ns478 0 -0.000184680824324
Gc3_479 0 n6 ns479 0 7.42384303227e-05
Gc3_480 0 n6 ns480 0 0.00033425632516
Gc3_481 0 n6 ns481 0 4.78610381536e-06
Gc3_482 0 n6 ns482 0 -5.20901987561e-06
Gc3_483 0 n6 ns483 0 1.32302966817e-06
Gc3_484 0 n6 ns484 0 4.51531626641e-06
Gc3_485 0 n6 ns485 0 -0.000697406017235
Gc3_486 0 n6 ns486 0 0.000433451673515
Gc3_487 0 n6 ns487 0 3.03429883508e-05
Gc3_488 0 n6 ns488 0 -3.2074166725e-05
Gc3_489 0 n6 ns489 0 -3.87460794836e-08
Gc3_490 0 n6 ns490 0 1.36089910867e-05
Gc3_491 0 n6 ns491 0 -0.000335871410102
Gc3_492 0 n6 ns492 0 -0.000499240271812
Gc3_493 0 n6 ns493 0 -8.67134474914e-06
Gc3_494 0 n6 ns494 0 0.000139266604297
Gc3_495 0 n6 ns495 0 -8.6840609677e-07
Gc3_496 0 n6 ns496 0 -1.78898121409e-06
Gc3_497 0 n6 ns497 0 8.61718279891e-05
Gc3_498 0 n6 ns498 0 0.000257925197981
Gc3_499 0 n6 ns499 0 6.02800036094e-05
Gc3_500 0 n6 ns500 0 9.81214923646e-05
Gc3_501 0 n6 ns501 0 -0.000202641054005
Gc3_502 0 n6 ns502 0 0.000253332729824
Gc3_503 0 n6 ns503 0 -0.000171996316715
Gc3_504 0 n6 ns504 0 0.000188035295968
Gc3_505 0 n6 ns505 0 -0.000448076096474
Gc3_506 0 n6 ns506 0 -5.73592184453e-05
Gc3_507 0 n6 ns507 0 -1.54741774584e-05
Gc3_508 0 n6 ns508 0 -3.58015995528e-06
Gc3_509 0 n6 ns509 0 4.33851397091e-05
Gc3_510 0 n6 ns510 0 -2.04036328099e-05
Gc3_511 0 n6 ns511 0 -0.000189356038369
Gc3_512 0 n6 ns512 0 -6.19942723025e-05
Gc3_513 0 n6 ns513 0 0.000142839490661
Gc3_514 0 n6 ns514 0 0.000400464006868
Gc3_515 0 n6 ns515 0 1.40105968316e-06
Gc3_516 0 n6 ns516 0 2.04495713023e-06
Gc3_517 0 n6 ns517 0 6.75359473644e-05
Gc3_518 0 n6 ns518 0 -5.87914403552e-05
Gc3_519 0 n6 ns519 0 1.43902069878e-06
Gc3_520 0 n6 ns520 0 4.74854614974e-07
Gc3_521 0 n6 ns521 0 -0.000957143734988
Gc3_522 0 n6 ns522 0 -0.000206143339434
Gc3_523 0 n6 ns523 0 -0.000323917555693
Gc3_524 0 n6 ns524 0 0.000618400990847
Gc3_525 0 n6 ns525 0 4.95790751456e-06
Gc3_526 0 n6 ns526 0 -1.36463280462e-05
Gc3_527 0 n6 ns527 0 -0.00015179335953
Gc3_528 0 n6 ns528 0 -0.000101850119391
Gc3_529 0 n6 ns529 0 -0.000215794151446
Gc3_530 0 n6 ns530 0 0.000189139335405
Gc3_531 0 n6 ns531 0 -0.00125024218616
Gc3_532 0 n6 ns532 0 0.00153642526313
Gc3_533 0 n6 ns533 0 3.5733819585e-05
Gc3_534 0 n6 ns534 0 -3.66387132766e-05
Gc3_535 0 n6 ns535 0 0.0339031684898
Gc3_536 0 n6 ns536 0 0.0188136747774
Gc3_537 0 n6 ns537 0 -0.0114582125527
Gc3_538 0 n6 ns538 0 0.0109225908046
Gc3_539 0 n6 ns539 0 0.00379813009205
Gc3_540 0 n6 ns540 0 -0.000134695963784
Gc3_541 0 n6 ns541 0 3.85205477436e-05
Gc3_542 0 n6 ns542 0 5.35494541815e-06
Gc3_543 0 n6 ns543 0 1.45737148427e-07
Gc3_544 0 n6 ns544 0 1.49699957665e-07
Gc3_545 0 n6 ns545 0 7.90564882111e-06
Gc3_546 0 n6 ns546 0 4.07205844545e-06
Gc3_547 0 n6 ns547 0 0.000401159611159
Gc3_548 0 n6 ns548 0 -1.58049048963e-05
Gc3_549 0 n6 ns549 0 -1.69588102382e-06
Gc3_550 0 n6 ns550 0 -8.58184843981e-07
Gc3_551 0 n6 ns551 0 -0.00409689238426
Gc3_552 0 n6 ns552 0 -0.00113215064509
Gc3_553 0 n6 ns553 0 5.25972962749e-05
Gc3_554 0 n6 ns554 0 -4.06182070917e-06
Gc3_555 0 n6 ns555 0 -0.000215396745787
Gc3_556 0 n6 ns556 0 0.000146231703022
Gc3_557 0 n6 ns557 0 -0.0019708441735
Gc3_558 0 n6 ns558 0 0.00764037530288
Gc3_559 0 n6 ns559 0 0.00554987666699
Gc3_560 0 n6 ns560 0 0.0142663698841
Gc3_561 0 n6 ns561 0 -3.55727854335e-05
Gc3_562 0 n6 ns562 0 5.74083627135e-05
Gc3_563 0 n6 ns563 0 1.63713589019e-06
Gc3_564 0 n6 ns564 0 -8.69835863794e-06
Gc3_565 0 n6 ns565 0 -2.71891734354e-05
Gc3_566 0 n6 ns566 0 -0.000102163437398
Gc3_567 0 n6 ns567 0 -0.000143737576839
Gc3_568 0 n6 ns568 0 -0.000257301837798
Gc3_569 0 n6 ns569 0 0.00181068882262
Gc3_570 0 n6 ns570 0 0.00102728364668
Gc3_571 0 n6 ns571 0 -7.91781398564e-06
Gc3_572 0 n6 ns572 0 7.35646724474e-06
Gc3_573 0 n6 ns573 0 -2.78458537997e-06
Gc3_574 0 n6 ns574 0 -1.45488158927e-05
Gc3_575 0 n6 ns575 0 1.26892445902e-05
Gc3_576 0 n6 ns576 0 -1.00504542487e-05
Gc3_577 0 n6 ns577 0 -1.08455506137e-05
Gc3_578 0 n6 ns578 0 -1.31930157512e-05
Gc3_579 0 n6 ns579 0 -1.79859573294e-05
Gc3_580 0 n6 ns580 0 -3.24036513356e-05
Gc3_581 0 n6 ns581 0 -6.38463173727e-05
Gc3_582 0 n6 ns582 0 -2.54179802816e-05
Gc3_583 0 n6 ns583 0 7.29753584573e-06
Gc3_584 0 n6 ns584 0 -1.4520421695e-06
Gc3_585 0 n6 ns585 0 2.01126828721e-05
Gc3_586 0 n6 ns586 0 -1.02253302775e-05
Gc3_587 0 n6 ns587 0 1.41445869084e-07
Gc3_588 0 n6 ns588 0 4.12833240278e-07
Gc3_589 0 n6 ns589 0 1.38572628514e-06
Gc3_590 0 n6 ns590 0 -1.03718597687e-05
Gc3_591 0 n6 ns591 0 -8.8432371489e-07
Gc3_592 0 n6 ns592 0 -7.14584218718e-06
Gc3_593 0 n6 ns593 0 -1.16521076724e-06
Gc3_594 0 n6 ns594 0 -1.5831217766e-06
Gc3_595 0 n6 ns595 0 1.46735203132e-06
Gc3_596 0 n6 ns596 0 -5.14939578002e-06
Gc3_597 0 n6 ns597 0 -4.25784316471e-06
Gc3_598 0 n6 ns598 0 4.1332316264e-07
Gc3_599 0 n6 ns599 0 -2.42354187376e-06
Gc3_600 0 n6 ns600 0 9.20335649932e-07
Gc3_601 0 n6 ns601 0 -0.000232049448291
Gc3_602 0 n6 ns602 0 -0.000972898754448
Gc3_603 0 n6 ns603 0 0.00103328535719
Gc3_604 0 n6 ns604 0 -0.00044534858034
Gc3_605 0 n6 ns605 0 -9.95901334516e-05
Gc3_606 0 n6 ns606 0 4.16098462586e-05
Gc3_607 0 n6 ns607 0 0.000184547055193
Gc3_608 0 n6 ns608 0 -0.000108561948099
Gc3_609 0 n6 ns609 0 -2.14441298302e-08
Gc3_610 0 n6 ns610 0 -5.06215206808e-08
Gc3_611 0 n6 ns611 0 1.4300328383e-05
Gc3_612 0 n6 ns612 0 -4.33491956948e-05
Gc3_613 0 n6 ns613 0 2.68592936684e-05
Gc3_614 0 n6 ns614 0 -5.7901044395e-05
Gc3_615 0 n6 ns615 0 -0.000151951027979
Gc3_616 0 n6 ns616 0 -9.27357885852e-05
Gc3_617 0 n6 ns617 0 3.61478857181e-05
Gc3_618 0 n6 ns618 0 -2.45135956973e-05
Gc3_619 0 n6 ns619 0 -0.000112721622584
Gc3_620 0 n6 ns620 0 7.55443787047e-05
Gc3_621 0 n6 ns621 0 9.06306265866e-05
Gc3_622 0 n6 ns622 0 -2.77137329244e-05
Gc3_623 0 n6 ns623 0 0.000125339445649
Gc3_624 0 n6 ns624 0 -0.00011935988845
Gc3_625 0 n6 ns625 0 2.45190050596e-06
Gc3_626 0 n6 ns626 0 -2.60359655498e-06
Gc3_627 0 n6 ns627 0 7.93517554373e-05
Gc3_628 0 n6 ns628 0 4.68872100609e-05
Gc3_629 0 n6 ns629 0 6.04030749368e-05
Gc3_630 0 n6 ns630 0 -0.000529896098119
Gc3_631 0 n6 ns631 0 -1.72811716818e-06
Gc3_632 0 n6 ns632 0 -8.47186429344e-07
Gc3_633 0 n6 ns633 0 1.07560037499e-06
Gc3_634 0 n6 ns634 0 3.95582932735e-06
Gc3_635 0 n6 ns635 0 -0.000191672834257
Gc3_636 0 n6 ns636 0 -6.26619524361e-05
Gc3_637 0 n6 ns637 0 3.04409996708e-05
Gc3_638 0 n6 ns638 0 1.14715523774e-05
Gc3_639 0 n6 ns639 0 -0.000120447360138
Gc3_640 0 n6 ns640 0 -6.80039814395e-05
Gc3_641 0 n6 ns641 0 0.000107266022326
Gc3_642 0 n6 ns642 0 6.04616169374e-05
Gc3_643 0 n6 ns643 0 5.17947032161e-05
Gc3_644 0 n6 ns644 0 -1.99881863876e-05
Gc3_645 0 n6 ns645 0 9.40144654878e-06
Gc3_646 0 n6 ns646 0 -4.90525978918e-06
Gc3_647 0 n6 ns647 0 5.90941170176e-05
Gc3_648 0 n6 ns648 0 -0.000190841283886
Gc3_649 0 n6 ns649 0 2.29865494098e-05
Gc3_650 0 n6 ns650 0 8.04775789942e-06
Gc3_651 0 n6 ns651 0 -0.000106336304906
Gc3_652 0 n6 ns652 0 -7.39064963287e-05
Gc3_653 0 n6 ns653 0 -7.60701779596e-05
Gc3_654 0 n6 ns654 0 -0.000149622344201
Gc3_655 0 n6 ns655 0 0.000408764432869
Gc3_656 0 n6 ns656 0 0.000236724035024
Gc3_657 0 n6 ns657 0 2.1910228498e-05
Gc3_658 0 n6 ns658 0 9.63572349927e-06
Gc3_659 0 n6 ns659 0 -1.37618029065e-05
Gc3_660 0 n6 ns660 0 1.13659093753e-06
Gc3_661 0 n6 ns661 0 7.72818888391e-05
Gc3_662 0 n6 ns662 0 4.65380427009e-05
Gc3_663 0 n6 ns663 0 0.000197987873418
Gc3_664 0 n6 ns664 0 -0.00128260760709
Gc3_665 0 n6 ns665 0 3.89905474064e-06
Gc3_666 0 n6 ns666 0 3.26743455465e-06
Gc3_667 0 n6 ns667 0 3.12602838002e-05
Gc3_668 0 n6 ns668 0 -4.61513071112e-05
Gc3_669 0 n6 ns669 0 2.27132511865e-07
Gc3_670 0 n6 ns670 0 4.16188331435e-07
Gc3_671 0 n6 ns671 0 -0.000114483131579
Gc3_672 0 n6 ns672 0 -0.000810414406331
Gc3_673 0 n6 ns673 0 -0.000348611679746
Gc3_674 0 n6 ns674 0 -8.07571856272e-05
Gc3_675 0 n6 ns675 0 1.33154934908e-05
Gc3_676 0 n6 ns676 0 -6.88645603258e-06
Gc3_677 0 n6 ns677 0 7.19595519599e-06
Gc3_678 0 n6 ns678 0 -1.1785325317e-05
Gc3_679 0 n6 ns679 0 5.45508928291e-05
Gc3_680 0 n6 ns680 0 -3.06911494839e-06
Gc3_681 0 n6 ns681 0 -0.000439100670067
Gc3_682 0 n6 ns682 0 -0.000665695611274
Gc3_683 0 n6 ns683 0 -2.66544312967e-05
Gc3_684 0 n6 ns684 0 3.17192276588e-05
Gc3_685 0 n6 ns685 0 -0.014627037104
Gc3_686 0 n6 ns686 0 0.0113650816879
Gc3_687 0 n6 ns687 0 0.00542349829163
Gc3_688 0 n6 ns688 0 0.00489001234558
Gc3_689 0 n6 ns689 0 -0.0141622173663
Gc3_690 0 n6 ns690 0 2.56235756068e-05
Gc3_691 0 n6 ns691 0 -1.56664902541e-05
Gc3_692 0 n6 ns692 0 -2.34864814736e-05
Gc3_693 0 n6 ns693 0 1.06793870677e-07
Gc3_694 0 n6 ns694 0 -2.37078353085e-08
Gc3_695 0 n6 ns695 0 -6.47653816777e-06
Gc3_696 0 n6 ns696 0 -5.87803881556e-06
Gc3_697 0 n6 ns697 0 0.000259228588519
Gc3_698 0 n6 ns698 0 -0.00115866035447
Gc3_699 0 n6 ns699 0 2.68225367507e-07
Gc3_700 0 n6 ns700 0 1.39629875826e-06
Gc3_701 0 n6 ns701 0 0.0026792131725
Gc3_702 0 n6 ns702 0 0.000157859814454
Gc3_703 0 n6 ns703 0 -1.1750636572e-05
Gc3_704 0 n6 ns704 0 2.65310937231e-05
Gc3_705 0 n6 ns705 0 -0.00029015093431
Gc3_706 0 n6 ns706 0 7.50907010951e-05
Gc3_707 0 n6 ns707 0 -0.00277483189527
Gc3_708 0 n6 ns708 0 -0.000611216527437
Gc3_709 0 n6 ns709 0 -0.00450272586449
Gc3_710 0 n6 ns710 0 0.00322131872137
Gc3_711 0 n6 ns711 0 -3.50896078595e-05
Gc3_712 0 n6 ns712 0 -5.08145701458e-05
Gc3_713 0 n6 ns713 0 -8.5932750081e-06
Gc3_714 0 n6 ns714 0 -7.18428052332e-06
Gc3_715 0 n6 ns715 0 3.88245918667e-06
Gc3_716 0 n6 ns716 0 -3.81189866935e-05
Gc3_717 0 n6 ns717 0 0.000196024533158
Gc3_718 0 n6 ns718 0 -1.85184422914e-06
Gc3_719 0 n6 ns719 0 -0.000371640742678
Gc3_720 0 n6 ns720 0 -0.00246223335336
Gc3_721 0 n6 ns721 0 -3.98966420667e-05
Gc3_722 0 n6 ns722 0 3.4591364708e-05
Gc3_723 0 n6 ns723 0 3.03838625642e-05
Gc3_724 0 n6 ns724 0 -1.79662007365e-06
Gc3_725 0 n6 ns725 0 5.22712788654e-06
Gc3_726 0 n6 ns726 0 2.52538467618e-05
Gc3_727 0 n6 ns727 0 5.73202273564e-06
Gc3_728 0 n6 ns728 0 2.48574047766e-05
Gc3_729 0 n6 ns729 0 2.85814881977e-05
Gc3_730 0 n6 ns730 0 1.98318425282e-05
Gc3_731 0 n6 ns731 0 4.02346071686e-05
Gc3_732 0 n6 ns732 0 -9.24623623362e-06
Gc3_733 0 n6 ns733 0 1.57472598025e-05
Gc3_734 0 n6 ns734 0 -8.30922855714e-06
Gc3_735 0 n6 ns735 0 -3.06308131737e-05
Gc3_736 0 n6 ns736 0 1.78801975622e-05
Gc3_737 0 n6 ns737 0 4.49936313544e-07
Gc3_738 0 n6 ns738 0 -7.25382070564e-07
Gc3_739 0 n6 ns739 0 3.30438343879e-05
Gc3_740 0 n6 ns740 0 -3.28271171253e-06
Gc3_741 0 n6 ns741 0 -3.88411884148e-06
Gc3_742 0 n6 ns742 0 1.99426453194e-06
Gc3_743 0 n6 ns743 0 -6.75719290379e-07
Gc3_744 0 n6 ns744 0 1.30425807086e-06
Gc3_745 0 n6 ns745 0 -2.03114265887e-06
Gc3_746 0 n6 ns746 0 1.09072068228e-07
Gc3_747 0 n6 ns747 0 -5.47657546793e-08
Gc3_748 0 n6 ns748 0 -5.69955096006e-08
Gc3_749 0 n6 ns749 0 -1.23669371558e-06
Gc3_750 0 n6 ns750 0 -2.51158782767e-07
Gc3_751 0 n6 ns751 0 0.000129123378887
Gc3_752 0 n6 ns752 0 0.00245953558164
Gc3_753 0 n6 ns753 0 -0.000562807943496
Gc3_754 0 n6 ns754 0 0.000153218002746
Gc3_755 0 n6 ns755 0 -0.000270837781165
Gc3_756 0 n6 ns756 0 3.40120529375e-06
Gc3_757 0 n6 ns757 0 -2.94002466836e-05
Gc3_758 0 n6 ns758 0 -1.60663069526e-05
Gc3_759 0 n6 ns759 0 1.04715572664e-08
Gc3_760 0 n6 ns760 0 1.12506533372e-07
Gc3_761 0 n6 ns761 0 3.9607433929e-05
Gc3_762 0 n6 ns762 0 0.0001221155375
Gc3_763 0 n6 ns763 0 -7.85042637324e-05
Gc3_764 0 n6 ns764 0 8.60872989808e-05
Gc3_765 0 n6 ns765 0 9.59015977598e-05
Gc3_766 0 n6 ns766 0 0.000156877696992
Gc3_767 0 n6 ns767 0 -0.000158960170273
Gc3_768 0 n6 ns768 0 0.000143404106651
Gc3_769 0 n6 ns769 0 -0.000177779510305
Gc3_770 0 n6 ns770 0 -0.00010670284702
Gc3_771 0 n6 ns771 0 1.44457395995e-05
Gc3_772 0 n6 ns772 0 -7.84980453276e-07
Gc3_773 0 n6 ns773 0 0.000183919453041
Gc3_774 0 n6 ns774 0 0.000370974349207
Gc3_775 0 n6 ns775 0 1.32266973334e-05
Gc3_776 0 n6 ns776 0 -7.37443975536e-06
Gc3_777 0 n6 ns777 0 0.000125953754617
Gc3_778 0 n6 ns778 0 9.91685153566e-07
Gc3_779 0 n6 ns779 0 -0.000790995012292
Gc3_780 0 n6 ns780 0 0.000360185391506
Gc3_781 0 n6 ns781 0 -2.95160264682e-06
Gc3_782 0 n6 ns782 0 6.84683283547e-07
Gc3_783 0 n6 ns783 0 -2.51474738925e-06
Gc3_784 0 n6 ns784 0 8.51960606197e-06
Gc3_785 0 n6 ns785 0 -6.94943536373e-05
Gc3_786 0 n6 ns786 0 4.18363802144e-05
Gc3_787 0 n6 ns787 0 -1.02240150651e-06
Gc3_788 0 n6 ns788 0 -2.14522570122e-05
Gc3_789 0 n6 ns789 0 5.34791194283e-05
Gc3_790 0 n6 ns790 0 9.74583957974e-05
Gc3_791 0 n6 ns791 0 0.000297234176709
Gc3_792 0 n6 ns792 0 0.00124785439925
Gc3_793 0 n6 ns793 0 -0.000115223734677
Gc3_794 0 n6 ns794 0 -3.56475258533e-05
Gc3_795 0 n6 ns795 0 6.78662696376e-06
Gc3_796 0 n6 ns796 0 -1.6498634366e-05
Gc3_797 0 n6 ns797 0 -6.26486253227e-05
Gc3_798 0 n6 ns798 0 0.000196875922946
Gc3_799 0 n6 ns799 0 3.74700629075e-05
Gc3_800 0 n6 ns800 0 9.76191194808e-05
Gc3_801 0 n6 ns801 0 -0.00010117864292
Gc3_802 0 n6 ns802 0 0.000105579683212
Gc3_803 0 n6 ns803 0 4.89865535879e-05
Gc3_804 0 n6 ns804 0 -3.31099133793e-06
Gc3_805 0 n6 ns805 0 0.000781917474402
Gc3_806 0 n6 ns806 0 0.000329239388233
Gc3_807 0 n6 ns807 0 -5.5156223889e-05
Gc3_808 0 n6 ns808 0 3.79615317858e-05
Gc3_809 0 n6 ns809 0 -8.38367130436e-06
Gc3_810 0 n6 ns810 0 -5.16063298371e-05
Gc3_811 0 n6 ns811 0 -0.000216518138852
Gc3_812 0 n6 ns812 0 0.00020091510541
Gc3_813 0 n6 ns813 0 0.000323993695563
Gc3_814 0 n6 ns814 0 0.00160969274891
Gc3_815 0 n6 ns815 0 1.12883348741e-06
Gc3_816 0 n6 ns816 0 1.16553696551e-05
Gc3_817 0 n6 ns817 0 2.67255109658e-05
Gc3_818 0 n6 ns818 0 -5.40359569335e-05
Gc3_819 0 n6 ns819 0 1.12412574184e-06
Gc3_820 0 n6 ns820 0 -5.5984104037e-07
Gc3_821 0 n6 ns821 0 0.000333676590217
Gc3_822 0 n6 ns822 0 -6.82880437169e-05
Gc3_823 0 n6 ns823 0 0.00027576155957
Gc3_824 0 n6 ns824 0 -0.000204172496462
Gc3_825 0 n6 ns825 0 1.39318290361e-05
Gc3_826 0 n6 ns826 0 -5.21817507385e-06
Gc3_827 0 n6 ns827 0 -9.71260164434e-05
Gc3_828 0 n6 ns828 0 1.06323457917e-05
Gc3_829 0 n6 ns829 0 -4.1541558387e-05
Gc3_830 0 n6 ns830 0 0.000164954792831
Gc3_831 0 n6 ns831 0 0.00191464708482
Gc3_832 0 n6 ns832 0 0.00309965915818
Gc3_833 0 n6 ns833 0 3.09838771112e-05
Gc3_834 0 n6 ns834 0 -5.79321577841e-05
Gc3_835 0 n6 ns835 0 -0.0150844917696
Gc3_836 0 n6 ns836 0 -0.00221217380888
Gc3_837 0 n6 ns837 0 -0.00505440677885
Gc3_838 0 n6 ns838 0 0.00740217618431
Gc3_839 0 n6 ns839 0 -0.0122133446207
Gc3_840 0 n6 ns840 0 -2.34217072083e-05
Gc3_841 0 n6 ns841 0 5.10626864715e-05
Gc3_842 0 n6 ns842 0 -2.40862993117e-06
Gc3_843 0 n6 ns843 0 1.10958355171e-07
Gc3_844 0 n6 ns844 0 -1.76304905486e-07
Gc3_845 0 n6 ns845 0 5.44311623184e-06
Gc3_846 0 n6 ns846 0 2.22688621047e-06
Gc3_847 0 n6 ns847 0 0.000283406522128
Gc3_848 0 n6 ns848 0 -0.000644250977717
Gc3_849 0 n6 ns849 0 -8.33144297642e-07
Gc3_850 0 n6 ns850 0 -5.33479280203e-07
Gc3_851 0 n6 ns851 0 -0.0015126940741
Gc3_852 0 n6 ns852 0 5.18204859245e-05
Gc3_853 0 n6 ns853 0 7.81555448768e-06
Gc3_854 0 n6 ns854 0 -6.46594870904e-06
Gc3_855 0 n6 ns855 0 -0.000217897858866
Gc3_856 0 n6 ns856 0 0.000139108047599
Gc3_857 0 n6 ns857 0 0.00774953899766
Gc3_858 0 n6 ns858 0 0.000517952196589
Gc3_859 0 n6 ns859 0 0.00540803693113
Gc3_860 0 n6 ns860 0 -0.00555598283174
Gc3_861 0 n6 ns861 0 1.40136902105e-05
Gc3_862 0 n6 ns862 0 6.12699166563e-05
Gc3_863 0 n6 ns863 0 -1.39762366761e-05
Gc3_864 0 n6 ns864 0 -1.06880146847e-05
Gc3_865 0 n6 ns865 0 -5.21363304613e-05
Gc3_866 0 n6 ns866 0 -6.46243283338e-05
Gc3_867 0 n6 ns867 0 -0.000381931800077
Gc3_868 0 n6 ns868 0 -0.000103401581768
Gc3_869 0 n6 ns869 0 0.00054817479295
Gc3_870 0 n6 ns870 0 -0.00238988576792
Gc3_871 0 n6 ns871 0 -2.63986384442e-05
Gc3_872 0 n6 ns872 0 -3.92007177348e-05
Gc3_873 0 n6 ns873 0 -6.88070686358e-06
Gc3_874 0 n6 ns874 0 -5.43245497892e-05
Gc3_875 0 n6 ns875 0 5.92318873456e-06
Gc3_876 0 n6 ns876 0 -2.79577183939e-05
Gc3_877 0 n6 ns877 0 -2.44939960612e-06
Gc3_878 0 n6 ns878 0 -1.85672167342e-05
Gc3_879 0 n6 ns879 0 -8.90269604794e-06
Gc3_880 0 n6 ns880 0 -2.42626348544e-05
Gc3_881 0 n6 ns881 0 -7.5792643966e-05
Gc3_882 0 n6 ns882 0 1.43197920689e-05
Gc3_883 0 n6 ns883 0 -9.81686352308e-08
Gc3_884 0 n6 ns884 0 3.30774904185e-06
Gc3_885 0 n6 ns885 0 2.79710223e-05
Gc3_886 0 n6 ns886 0 -1.04767846647e-05
Gc3_887 0 n6 ns887 0 -2.00375189466e-06
Gc3_888 0 n6 ns888 0 5.78089358023e-07
Gc3_889 0 n6 ns889 0 2.78064344213e-05
Gc3_890 0 n6 ns890 0 4.19727488279e-05
Gc3_891 0 n6 ns891 0 4.5150495846e-06
Gc3_892 0 n6 ns892 0 -4.81358419424e-07
Gc3_893 0 n6 ns893 0 5.07399387699e-07
Gc3_894 0 n6 ns894 0 -1.50642868777e-06
Gc3_895 0 n6 ns895 0 1.31593981283e-06
Gc3_896 0 n6 ns896 0 3.31077061206e-06
Gc3_897 0 n6 ns897 0 6.06393914722e-06
Gc3_898 0 n6 ns898 0 -1.0834571622e-05
Gc3_899 0 n6 ns899 0 1.00643039879e-06
Gc3_900 0 n6 ns900 0 -2.94234991196e-06
Gd3_1 0 n6 ni1 0 0.000871080628863
Gd3_2 0 n6 ni2 0 6.40134574296e-06
Gd3_3 0 n6 ni3 0 -0.00843029985873
Gd3_4 0 n6 ni4 0 -0.00025553865698
Gd3_5 0 n6 ni5 0 0.0011517913878
Gd3_6 0 n6 ni6 0 0.000541755845258
Gc4_1 0 n8 ns1 0 0.00126627970673
Gc4_2 0 n8 ns2 0 0.0006350575739
Gc4_3 0 n8 ns3 0 -0.00103318992965
Gc4_4 0 n8 ns4 0 -0.000121588472831
Gc4_5 0 n8 ns5 0 -8.35198520894e-05
Gc4_6 0 n8 ns6 0 -2.06256173375e-05
Gc4_7 0 n8 ns7 0 -0.00018553599953
Gc4_8 0 n8 ns8 0 2.63121960914e-05
Gc4_9 0 n8 ns9 0 -7.48817966877e-08
Gc4_10 0 n8 ns10 0 2.16285471834e-08
Gc4_11 0 n8 ns11 0 -9.16828008762e-05
Gc4_12 0 n8 ns12 0 0.000120685914925
Gc4_13 0 n8 ns13 0 -4.14914436554e-05
Gc4_14 0 n8 ns14 0 3.66394033472e-05
Gc4_15 0 n8 ns15 0 5.53468049602e-05
Gc4_16 0 n8 ns16 0 6.1671674662e-05
Gc4_17 0 n8 ns17 0 -8.87014850731e-05
Gc4_18 0 n8 ns18 0 0.000151052998232
Gc4_19 0 n8 ns19 0 -0.000270473606039
Gc4_20 0 n8 ns20 0 2.70590743146e-05
Gc4_21 0 n8 ns21 0 -9.89515854952e-06
Gc4_22 0 n8 ns22 0 6.23172884713e-05
Gc4_23 0 n8 ns23 0 -0.000164359393901
Gc4_24 0 n8 ns24 0 0.000165688290644
Gc4_25 0 n8 ns25 0 2.39855284576e-05
Gc4_26 0 n8 ns26 0 2.52642778717e-07
Gc4_27 0 n8 ns27 0 0.000125283572101
Gc4_28 0 n8 ns28 0 3.16704605669e-05
Gc4_29 0 n8 ns29 0 -0.000635148547326
Gc4_30 0 n8 ns30 0 0.000680106778104
Gc4_31 0 n8 ns31 0 -5.0267518779e-06
Gc4_32 0 n8 ns32 0 2.82488470451e-06
Gc4_33 0 n8 ns33 0 4.44428036418e-06
Gc4_34 0 n8 ns34 0 1.18882445582e-05
Gc4_35 0 n8 ns35 0 -0.000382752395043
Gc4_36 0 n8 ns36 0 9.90574033762e-05
Gc4_37 0 n8 ns37 0 1.81431165138e-05
Gc4_38 0 n8 ns38 0 -2.62281582641e-05
Gc4_39 0 n8 ns39 0 -1.17807970636e-05
Gc4_40 0 n8 ns40 0 9.31699433522e-05
Gc4_41 0 n8 ns41 0 0.000621079946052
Gc4_42 0 n8 ns42 0 0.00133030607755
Gc4_43 0 n8 ns43 0 -0.000136651981314
Gc4_44 0 n8 ns44 0 -5.04096569129e-05
Gc4_45 0 n8 ns45 0 9.21967682363e-06
Gc4_46 0 n8 ns46 0 -1.20301729282e-05
Gc4_47 0 n8 ns47 0 -0.000105245588663
Gc4_48 0 n8 ns48 0 0.000257786039713
Gc4_49 0 n8 ns49 0 5.32619944807e-05
Gc4_50 0 n8 ns50 0 9.50448297984e-05
Gc4_51 0 n8 ns51 0 -0.000108950410611
Gc4_52 0 n8 ns52 0 8.00223182616e-05
Gc4_53 0 n8 ns53 0 4.38859913456e-05
Gc4_54 0 n8 ns54 0 2.25144535085e-05
Gc4_55 0 n8 ns55 0 0.000734691373023
Gc4_56 0 n8 ns56 0 0.000204839143771
Gc4_57 0 n8 ns57 0 -6.12550540989e-05
Gc4_58 0 n8 ns58 0 3.81577389255e-05
Gc4_59 0 n8 ns59 0 5.98094820743e-06
Gc4_60 0 n8 ns60 0 -4.28831031834e-05
Gc4_61 0 n8 ns61 0 -0.000211320846299
Gc4_62 0 n8 ns62 0 0.000104319997231
Gc4_63 0 n8 ns63 0 0.000243054103553
Gc4_64 0 n8 ns64 0 0.00173898964728
Gc4_65 0 n8 ns65 0 6.29917070819e-06
Gc4_66 0 n8 ns66 0 1.44768006583e-05
Gc4_67 0 n8 ns67 0 4.54550088359e-05
Gc4_68 0 n8 ns68 0 -2.38959843019e-05
Gc4_69 0 n8 ns69 0 8.27562456853e-07
Gc4_70 0 n8 ns70 0 -2.18129255363e-08
Gc4_71 0 n8 ns71 0 0.000221846882293
Gc4_72 0 n8 ns72 0 -0.000196938432875
Gc4_73 0 n8 ns73 0 0.000183774647441
Gc4_74 0 n8 ns74 0 -0.000129993948255
Gc4_75 0 n8 ns75 0 9.88854029624e-06
Gc4_76 0 n8 ns76 0 -1.19430264533e-06
Gc4_77 0 n8 ns77 0 -0.00010430936312
Gc4_78 0 n8 ns78 0 2.54643322616e-05
Gc4_79 0 n8 ns79 0 -1.99084550919e-05
Gc4_80 0 n8 ns80 0 0.000176664379686
Gc4_81 0 n8 ns81 0 0.0019275761366
Gc4_82 0 n8 ns82 0 0.0028964115051
Gc4_83 0 n8 ns83 0 3.69218362546e-05
Gc4_84 0 n8 ns84 0 -4.81452325593e-05
Gc4_85 0 n8 ns85 0 -0.0144472128051
Gc4_86 0 n8 ns86 0 -0.00215370391503
Gc4_87 0 n8 ns87 0 -0.00479212080553
Gc4_88 0 n8 ns88 0 0.0069155096219
Gc4_89 0 n8 ns89 0 -0.0110934856454
Gc4_90 0 n8 ns90 0 -2.19645735371e-05
Gc4_91 0 n8 ns91 0 3.94163721019e-05
Gc4_92 0 n8 ns92 0 1.57510791213e-06
Gc4_93 0 n8 ns93 0 6.28342519315e-08
Gc4_94 0 n8 ns94 0 -8.91555658736e-08
Gc4_95 0 n8 ns95 0 4.73542542479e-06
Gc4_96 0 n8 ns96 0 5.79892134201e-06
Gc4_97 0 n8 ns97 0 0.000150866305117
Gc4_98 0 n8 ns98 0 -0.000563904016355
Gc4_99 0 n8 ns99 0 -5.08416212921e-07
Gc4_100 0 n8 ns100 0 -7.05794802486e-07
Gc4_101 0 n8 ns101 0 -0.00147996440294
Gc4_102 0 n8 ns102 0 8.66581683874e-05
Gc4_103 0 n8 ns103 0 6.93620289379e-06
Gc4_104 0 n8 ns104 0 -6.15365385831e-06
Gc4_105 0 n8 ns105 0 -0.000188295245255
Gc4_106 0 n8 ns106 0 9.89926115591e-05
Gc4_107 0 n8 ns107 0 0.00692940937033
Gc4_108 0 n8 ns108 0 0.000463962488786
Gc4_109 0 n8 ns109 0 0.00452937975493
Gc4_110 0 n8 ns110 0 -0.00487704164433
Gc4_111 0 n8 ns111 0 1.01156876018e-05
Gc4_112 0 n8 ns112 0 4.11851854356e-05
Gc4_113 0 n8 ns113 0 -1.18674367487e-05
Gc4_114 0 n8 ns114 0 -9.40622319978e-06
Gc4_115 0 n8 ns115 0 -3.07020107858e-05
Gc4_116 0 n8 ns116 0 -5.2240350014e-05
Gc4_117 0 n8 ns117 0 -0.000276154863099
Gc4_118 0 n8 ns118 0 -0.00010755810711
Gc4_119 0 n8 ns119 0 0.000417678843476
Gc4_120 0 n8 ns120 0 -0.00242441736403
Gc4_121 0 n8 ns121 0 -2.34670115731e-05
Gc4_122 0 n8 ns122 0 -3.21040246067e-05
Gc4_123 0 n8 ns123 0 -3.19553687629e-07
Gc4_124 0 n8 ns124 0 -4.47791522883e-05
Gc4_125 0 n8 ns125 0 4.1274830468e-06
Gc4_126 0 n8 ns126 0 -2.14428181557e-05
Gc4_127 0 n8 ns127 0 -1.59756499042e-06
Gc4_128 0 n8 ns128 0 -1.33760935653e-05
Gc4_129 0 n8 ns129 0 -3.68176953164e-06
Gc4_130 0 n8 ns130 0 -2.49356768414e-05
Gc4_131 0 n8 ns131 0 -7.02309954251e-05
Gc4_132 0 n8 ns132 0 4.3424179515e-06
Gc4_133 0 n8 ns133 0 1.11872387907e-06
Gc4_134 0 n8 ns134 0 1.09452266263e-06
Gc4_135 0 n8 ns135 0 2.28079629354e-05
Gc4_136 0 n8 ns136 0 -5.28802563893e-06
Gc4_137 0 n8 ns137 0 -1.6607642944e-06
Gc4_138 0 n8 ns138 0 3.88497266734e-07
Gc4_139 0 n8 ns139 0 2.93678054709e-05
Gc4_140 0 n8 ns140 0 4.00731656817e-05
Gc4_141 0 n8 ns141 0 4.76342514825e-06
Gc4_142 0 n8 ns142 0 -4.4665245194e-07
Gc4_143 0 n8 ns143 0 6.67522882955e-07
Gc4_144 0 n8 ns144 0 -1.46630462557e-06
Gc4_145 0 n8 ns145 0 1.64697217774e-06
Gc4_146 0 n8 ns146 0 3.59138895898e-06
Gc4_147 0 n8 ns147 0 5.86362312387e-06
Gc4_148 0 n8 ns148 0 -1.01975283114e-05
Gc4_149 0 n8 ns149 0 6.89081871602e-07
Gc4_150 0 n8 ns150 0 -3.05443649374e-06
Gc4_151 0 n8 ns151 0 0.000834924686168
Gc4_152 0 n8 ns152 0 -0.0020902318862
Gc4_153 0 n8 ns153 0 0.000349063189957
Gc4_154 0 n8 ns154 0 -0.000373533954901
Gc4_155 0 n8 ns155 0 4.33153371894e-05
Gc4_156 0 n8 ns156 0 1.99621608807e-05
Gc4_157 0 n8 ns157 0 -6.248270184e-05
Gc4_158 0 n8 ns158 0 -1.96654061812e-05
Gc4_159 0 n8 ns159 0 9.28549372621e-08
Gc4_160 0 n8 ns160 0 6.8676162083e-09
Gc4_161 0 n8 ns161 0 6.7826294933e-05
Gc4_162 0 n8 ns162 0 9.37657058003e-05
Gc4_163 0 n8 ns163 0 6.40385782157e-05
Gc4_164 0 n8 ns164 0 7.64960802022e-06
Gc4_165 0 n8 ns165 0 8.88350268342e-05
Gc4_166 0 n8 ns166 0 -6.56957471903e-05
Gc4_167 0 n8 ns167 0 0.000237000794118
Gc4_168 0 n8 ns168 0 -0.000175413457627
Gc4_169 0 n8 ns169 0 4.21493308291e-05
Gc4_170 0 n8 ns170 0 -0.000185129627816
Gc4_171 0 n8 ns171 0 -2.38344808271e-05
Gc4_172 0 n8 ns172 0 -7.31948282215e-05
Gc4_173 0 n8 ns173 0 -8.51706368758e-05
Gc4_174 0 n8 ns174 0 8.01812519656e-05
Gc4_175 0 n8 ns175 0 1.97067598988e-05
Gc4_176 0 n8 ns176 0 -4.01309567064e-06
Gc4_177 0 n8 ns177 0 1.75510135582e-05
Gc4_178 0 n8 ns178 0 2.60528110659e-05
Gc4_179 0 n8 ns179 0 0.00011077753422
Gc4_180 0 n8 ns180 0 -8.82554031863e-05
Gc4_181 0 n8 ns181 0 4.43322714626e-06
Gc4_182 0 n8 ns182 0 -7.36283401913e-06
Gc4_183 0 n8 ns183 0 1.00995174129e-05
Gc4_184 0 n8 ns184 0 2.10615026696e-06
Gc4_185 0 n8 ns185 0 0.000169391225139
Gc4_186 0 n8 ns186 0 -0.000124608937129
Gc4_187 0 n8 ns187 0 -2.94152745564e-05
Gc4_188 0 n8 ns188 0 8.67411744102e-06
Gc4_189 0 n8 ns189 0 1.65677521981e-05
Gc4_190 0 n8 ns190 0 4.91898612067e-05
Gc4_191 0 n8 ns191 0 0.000498630685038
Gc4_192 0 n8 ns192 0 -0.000130982558808
Gc4_193 0 n8 ns193 0 -9.02818413905e-05
Gc4_194 0 n8 ns194 0 1.16084119228e-05
Gc4_195 0 n8 ns195 0 -2.0733411042e-06
Gc4_196 0 n8 ns196 0 1.05384979313e-05
Gc4_197 0 n8 ns197 0 4.7898006726e-05
Gc4_198 0 n8 ns198 0 3.19028675755e-05
Gc4_199 0 n8 ns199 0 4.04440689805e-05
Gc4_200 0 n8 ns200 0 -8.53061927738e-06
Gc4_201 0 n8 ns201 0 2.37144780784e-05
Gc4_202 0 n8 ns202 0 7.28463642155e-05
Gc4_203 0 n8 ns203 0 -7.6142711496e-06
Gc4_204 0 n8 ns204 0 -0.000120323390814
Gc4_205 0 n8 ns205 0 0.000264103099162
Gc4_206 0 n8 ns206 0 2.27039197566e-05
Gc4_207 0 n8 ns207 0 2.16949795656e-05
Gc4_208 0 n8 ns208 0 2.0035560928e-05
Gc4_209 0 n8 ns209 0 -1.7854855423e-05
Gc4_210 0 n8 ns210 0 4.44285771367e-05
Gc4_211 0 n8 ns211 0 0.000190590329258
Gc4_212 0 n8 ns212 0 -7.7657004797e-05
Gc4_213 0 n8 ns213 0 -0.000144138196131
Gc4_214 0 n8 ns214 0 -0.000674869571514
Gc4_215 0 n8 ns215 0 -1.0041545005e-05
Gc4_216 0 n8 ns216 0 2.7768413774e-06
Gc4_217 0 n8 ns217 0 1.18526765414e-05
Gc4_218 0 n8 ns218 0 1.60503622207e-05
Gc4_219 0 n8 ns219 0 -5.98635481255e-08
Gc4_220 0 n8 ns220 0 2.22783357976e-07
Gc4_221 0 n8 ns221 0 0.000298974330099
Gc4_222 0 n8 ns222 0 -0.000316467257764
Gc4_223 0 n8 ns223 0 -9.19535965246e-05
Gc4_224 0 n8 ns224 0 -0.000323553748174
Gc4_225 0 n8 ns225 0 1.36260184062e-05
Gc4_226 0 n8 ns226 0 -3.05110059163e-06
Gc4_227 0 n8 ns227 0 -1.42671217734e-05
Gc4_228 0 n8 ns228 0 2.67611174651e-05
Gc4_229 0 n8 ns229 0 0.000110476566028
Gc4_230 0 n8 ns230 0 2.08058238658e-05
Gc4_231 0 n8 ns231 0 -0.000366616640068
Gc4_232 0 n8 ns232 0 -0.00186872048249
Gc4_233 0 n8 ns233 0 -4.00028411391e-05
Gc4_234 0 n8 ns234 0 5.00545475562e-06
Gc4_235 0 n8 ns235 0 -0.0157380835976
Gc4_236 0 n8 ns236 0 0.0112867954778
Gc4_237 0 n8 ns237 0 0.00556316115931
Gc4_238 0 n8 ns238 0 0.00675272134455
Gc4_239 0 n8 ns239 0 -0.0134401792897
Gc4_240 0 n8 ns240 0 2.40199820088e-05
Gc4_241 0 n8 ns241 0 -2.7568458742e-05
Gc4_242 0 n8 ns242 0 1.35404844338e-05
Gc4_243 0 n8 ns243 0 -1.46092409438e-07
Gc4_244 0 n8 ns244 0 -1.31702515553e-07
Gc4_245 0 n8 ns245 0 -2.20211232651e-06
Gc4_246 0 n8 ns246 0 -1.53951435048e-05
Gc4_247 0 n8 ns247 0 0.000145643850306
Gc4_248 0 n8 ns248 0 -0.00110169837972
Gc4_249 0 n8 ns249 0 2.75039216408e-07
Gc4_250 0 n8 ns250 0 3.67337720283e-07
Gc4_251 0 n8 ns251 0 0.00204068946482
Gc4_252 0 n8 ns252 0 0.000563433294423
Gc4_253 0 n8 ns253 0 -5.32084409835e-07
Gc4_254 0 n8 ns254 0 2.61378192331e-06
Gc4_255 0 n8 ns255 0 -0.000308724307679
Gc4_256 0 n8 ns256 0 4.43845949466e-05
Gc4_257 0 n8 ns257 0 -0.00325269707417
Gc4_258 0 n8 ns258 0 -0.00160002861173
Gc4_259 0 n8 ns259 0 -0.00404396498647
Gc4_260 0 n8 ns260 0 0.00287916058144
Gc4_261 0 n8 ns261 0 7.52685934614e-05
Gc4_262 0 n8 ns262 0 2.07993385761e-05
Gc4_263 0 n8 ns263 0 -1.29775392673e-05
Gc4_264 0 n8 ns264 0 3.29715058669e-06
Gc4_265 0 n8 ns265 0 1.15956817219e-05
Gc4_266 0 n8 ns266 0 -2.624439414e-05
Gc4_267 0 n8 ns267 0 0.000186515161944
Gc4_268 0 n8 ns268 0 0.000290989371447
Gc4_269 0 n8 ns269 0 -0.00113652603912
Gc4_270 0 n8 ns270 0 -0.00211631589749
Gc4_271 0 n8 ns271 0 3.81577146684e-05
Gc4_272 0 n8 ns272 0 -6.79057001685e-05
Gc4_273 0 n8 ns273 0 -1.81243149743e-05
Gc4_274 0 n8 ns274 0 4.70499931594e-06
Gc4_275 0 n8 ns275 0 -1.91348036333e-05
Gc4_276 0 n8 ns276 0 6.37694137582e-06
Gc4_277 0 n8 ns277 0 -7.98798161749e-06
Gc4_278 0 n8 ns278 0 2.16686329186e-05
Gc4_279 0 n8 ns279 0 -1.64087847569e-05
Gc4_280 0 n8 ns280 0 -1.43449722228e-05
Gc4_281 0 n8 ns281 0 2.93491540289e-05
Gc4_282 0 n8 ns282 0 2.46538416275e-05
Gc4_283 0 n8 ns283 0 1.27214553264e-05
Gc4_284 0 n8 ns284 0 -1.88539643354e-05
Gc4_285 0 n8 ns285 0 -3.49862812947e-05
Gc4_286 0 n8 ns286 0 4.66472088395e-06
Gc4_287 0 n8 ns287 0 3.56739729115e-07
Gc4_288 0 n8 ns288 0 1.34526061761e-08
Gc4_289 0 n8 ns289 0 9.22271786103e-06
Gc4_290 0 n8 ns290 0 -6.5028335587e-06
Gc4_291 0 n8 ns291 0 -2.01444294551e-06
Gc4_292 0 n8 ns292 0 1.79647787062e-07
Gc4_293 0 n8 ns293 0 -3.84667470109e-07
Gc4_294 0 n8 ns294 0 -1.53555340367e-07
Gc4_295 0 n8 ns295 0 2.26377680908e-06
Gc4_296 0 n8 ns296 0 3.19953113135e-07
Gc4_297 0 n8 ns297 0 3.44553458771e-06
Gc4_298 0 n8 ns298 0 -9.00861994494e-09
Gc4_299 0 n8 ns299 0 8.11371024618e-07
Gc4_300 0 n8 ns300 0 -4.57194218773e-07
Gc4_301 0 n8 ns301 0 -0.000774272420436
Gc4_302 0 n8 ns302 0 0.00228740227924
Gc4_303 0 n8 ns303 0 -0.00010794763119
Gc4_304 0 n8 ns304 0 -0.000496802561019
Gc4_305 0 n8 ns305 0 0.000441967324389
Gc4_306 0 n8 ns306 0 1.44660165528e-05
Gc4_307 0 n8 ns307 0 -0.000279023538044
Gc4_308 0 n8 ns308 0 -8.0787752245e-06
Gc4_309 0 n8 ns309 0 -2.85829892296e-10
Gc4_310 0 n8 ns310 0 -5.15811689053e-09
Gc4_311 0 n8 ns311 0 -0.000278166028605
Gc4_312 0 n8 ns312 0 -0.000131375190698
Gc4_313 0 n8 ns313 0 1.80146957382e-05
Gc4_314 0 n8 ns314 0 -0.000144259545312
Gc4_315 0 n8 ns315 0 3.53091797958e-05
Gc4_316 0 n8 ns316 0 -0.000213530765341
Gc4_317 0 n8 ns317 0 8.71788596346e-05
Gc4_318 0 n8 ns318 0 8.87836049251e-06
Gc4_319 0 n8 ns319 0 -0.000183452400417
Gc4_320 0 n8 ns320 0 0.000240944856112
Gc4_321 0 n8 ns321 0 6.04253598805e-06
Gc4_322 0 n8 ns322 0 0.000130076385193
Gc4_323 0 n8 ns323 0 -0.000723372891481
Gc4_324 0 n8 ns324 0 -0.000416774940558
Gc4_325 0 n8 ns325 0 1.19383731156e-06
Gc4_326 0 n8 ns326 0 1.59894293564e-05
Gc4_327 0 n8 ns327 0 0.000110216155831
Gc4_328 0 n8 ns328 0 -0.000184680824324
Gc4_329 0 n8 ns329 0 7.42384303227e-05
Gc4_330 0 n8 ns330 0 0.00033425632516
Gc4_331 0 n8 ns331 0 4.78610381536e-06
Gc4_332 0 n8 ns332 0 -5.20901987561e-06
Gc4_333 0 n8 ns333 0 1.32302966817e-06
Gc4_334 0 n8 ns334 0 4.51531626641e-06
Gc4_335 0 n8 ns335 0 -0.000697406017235
Gc4_336 0 n8 ns336 0 0.000433451673515
Gc4_337 0 n8 ns337 0 3.03429883508e-05
Gc4_338 0 n8 ns338 0 -3.2074166725e-05
Gc4_339 0 n8 ns339 0 -3.87460794836e-08
Gc4_340 0 n8 ns340 0 1.36089910867e-05
Gc4_341 0 n8 ns341 0 -0.000335871410102
Gc4_342 0 n8 ns342 0 -0.000499240271812
Gc4_343 0 n8 ns343 0 -8.67134474914e-06
Gc4_344 0 n8 ns344 0 0.000139266604297
Gc4_345 0 n8 ns345 0 -8.6840609677e-07
Gc4_346 0 n8 ns346 0 -1.78898121409e-06
Gc4_347 0 n8 ns347 0 8.61718279891e-05
Gc4_348 0 n8 ns348 0 0.000257925197981
Gc4_349 0 n8 ns349 0 6.02800036094e-05
Gc4_350 0 n8 ns350 0 9.81214923646e-05
Gc4_351 0 n8 ns351 0 -0.000202641054005
Gc4_352 0 n8 ns352 0 0.000253332729824
Gc4_353 0 n8 ns353 0 -0.000171996316715
Gc4_354 0 n8 ns354 0 0.000188035295968
Gc4_355 0 n8 ns355 0 -0.000448076096474
Gc4_356 0 n8 ns356 0 -5.73592184453e-05
Gc4_357 0 n8 ns357 0 -1.54741774584e-05
Gc4_358 0 n8 ns358 0 -3.58015995528e-06
Gc4_359 0 n8 ns359 0 4.33851397091e-05
Gc4_360 0 n8 ns360 0 -2.04036328099e-05
Gc4_361 0 n8 ns361 0 -0.000189356038369
Gc4_362 0 n8 ns362 0 -6.19942723025e-05
Gc4_363 0 n8 ns363 0 0.000142839490661
Gc4_364 0 n8 ns364 0 0.000400464006868
Gc4_365 0 n8 ns365 0 1.40105968316e-06
Gc4_366 0 n8 ns366 0 2.04495713023e-06
Gc4_367 0 n8 ns367 0 6.75359473644e-05
Gc4_368 0 n8 ns368 0 -5.87914403552e-05
Gc4_369 0 n8 ns369 0 1.43902069878e-06
Gc4_370 0 n8 ns370 0 4.74854614974e-07
Gc4_371 0 n8 ns371 0 -0.000957143734988
Gc4_372 0 n8 ns372 0 -0.000206143339434
Gc4_373 0 n8 ns373 0 -0.000323917555693
Gc4_374 0 n8 ns374 0 0.000618400990847
Gc4_375 0 n8 ns375 0 4.95790751456e-06
Gc4_376 0 n8 ns376 0 -1.36463280462e-05
Gc4_377 0 n8 ns377 0 -0.00015179335953
Gc4_378 0 n8 ns378 0 -0.000101850119391
Gc4_379 0 n8 ns379 0 -0.000215794151446
Gc4_380 0 n8 ns380 0 0.000189139335405
Gc4_381 0 n8 ns381 0 -0.00125024218616
Gc4_382 0 n8 ns382 0 0.00153642526313
Gc4_383 0 n8 ns383 0 3.5733819585e-05
Gc4_384 0 n8 ns384 0 -3.66387132766e-05
Gc4_385 0 n8 ns385 0 0.0339031684898
Gc4_386 0 n8 ns386 0 0.0188136747774
Gc4_387 0 n8 ns387 0 -0.0114582125527
Gc4_388 0 n8 ns388 0 0.0109225908046
Gc4_389 0 n8 ns389 0 0.00379813009205
Gc4_390 0 n8 ns390 0 -0.000134695963784
Gc4_391 0 n8 ns391 0 3.85205477436e-05
Gc4_392 0 n8 ns392 0 5.35494541815e-06
Gc4_393 0 n8 ns393 0 1.45737148427e-07
Gc4_394 0 n8 ns394 0 1.49699957665e-07
Gc4_395 0 n8 ns395 0 7.90564882111e-06
Gc4_396 0 n8 ns396 0 4.07205844545e-06
Gc4_397 0 n8 ns397 0 0.000401159611159
Gc4_398 0 n8 ns398 0 -1.58049048963e-05
Gc4_399 0 n8 ns399 0 -1.69588102382e-06
Gc4_400 0 n8 ns400 0 -8.58184843981e-07
Gc4_401 0 n8 ns401 0 -0.00409689238426
Gc4_402 0 n8 ns402 0 -0.00113215064509
Gc4_403 0 n8 ns403 0 5.25972962749e-05
Gc4_404 0 n8 ns404 0 -4.06182070917e-06
Gc4_405 0 n8 ns405 0 -0.000215396745787
Gc4_406 0 n8 ns406 0 0.000146231703022
Gc4_407 0 n8 ns407 0 -0.0019708441735
Gc4_408 0 n8 ns408 0 0.00764037530288
Gc4_409 0 n8 ns409 0 0.00554987666699
Gc4_410 0 n8 ns410 0 0.0142663698841
Gc4_411 0 n8 ns411 0 -3.55727854335e-05
Gc4_412 0 n8 ns412 0 5.74083627135e-05
Gc4_413 0 n8 ns413 0 1.63713589019e-06
Gc4_414 0 n8 ns414 0 -8.69835863794e-06
Gc4_415 0 n8 ns415 0 -2.71891734354e-05
Gc4_416 0 n8 ns416 0 -0.000102163437398
Gc4_417 0 n8 ns417 0 -0.000143737576839
Gc4_418 0 n8 ns418 0 -0.000257301837798
Gc4_419 0 n8 ns419 0 0.00181068882262
Gc4_420 0 n8 ns420 0 0.00102728364668
Gc4_421 0 n8 ns421 0 -7.91781398564e-06
Gc4_422 0 n8 ns422 0 7.35646724474e-06
Gc4_423 0 n8 ns423 0 -2.78458537997e-06
Gc4_424 0 n8 ns424 0 -1.45488158927e-05
Gc4_425 0 n8 ns425 0 1.26892445902e-05
Gc4_426 0 n8 ns426 0 -1.00504542487e-05
Gc4_427 0 n8 ns427 0 -1.08455506137e-05
Gc4_428 0 n8 ns428 0 -1.31930157512e-05
Gc4_429 0 n8 ns429 0 -1.79859573294e-05
Gc4_430 0 n8 ns430 0 -3.24036513356e-05
Gc4_431 0 n8 ns431 0 -6.38463173727e-05
Gc4_432 0 n8 ns432 0 -2.54179802816e-05
Gc4_433 0 n8 ns433 0 7.29753584573e-06
Gc4_434 0 n8 ns434 0 -1.4520421695e-06
Gc4_435 0 n8 ns435 0 2.01126828721e-05
Gc4_436 0 n8 ns436 0 -1.02253302775e-05
Gc4_437 0 n8 ns437 0 1.41445869084e-07
Gc4_438 0 n8 ns438 0 4.12833240278e-07
Gc4_439 0 n8 ns439 0 1.38572628514e-06
Gc4_440 0 n8 ns440 0 -1.03718597687e-05
Gc4_441 0 n8 ns441 0 -8.8432371489e-07
Gc4_442 0 n8 ns442 0 -7.14584218718e-06
Gc4_443 0 n8 ns443 0 -1.16521076724e-06
Gc4_444 0 n8 ns444 0 -1.5831217766e-06
Gc4_445 0 n8 ns445 0 1.46735203132e-06
Gc4_446 0 n8 ns446 0 -5.14939578002e-06
Gc4_447 0 n8 ns447 0 -4.25784316471e-06
Gc4_448 0 n8 ns448 0 4.1332316264e-07
Gc4_449 0 n8 ns449 0 -2.42354187376e-06
Gc4_450 0 n8 ns450 0 9.20335649932e-07
Gc4_451 0 n8 ns451 0 -0.00649406205549
Gc4_452 0 n8 ns452 0 0.00409611237274
Gc4_453 0 n8 ns453 0 -0.00136553361767
Gc4_454 0 n8 ns454 0 -6.95880399132e-05
Gc4_455 0 n8 ns455 0 -5.04820679848e-05
Gc4_456 0 n8 ns456 0 -0.000206791135688
Gc4_457 0 n8 ns457 0 9.1780321839e-05
Gc4_458 0 n8 ns458 0 -1.09277110774e-05
Gc4_459 0 n8 ns459 0 5.4894260167e-08
Gc4_460 0 n8 ns460 0 -1.84863227643e-07
Gc4_461 0 n8 ns461 0 1.07093551593e-05
Gc4_462 0 n8 ns462 0 6.09651309279e-05
Gc4_463 0 n8 ns463 0 6.63479687301e-05
Gc4_464 0 n8 ns464 0 -4.0530380758e-05
Gc4_465 0 n8 ns465 0 0.000108551347559
Gc4_466 0 n8 ns466 0 -9.93744812568e-05
Gc4_467 0 n8 ns467 0 -1.43398070553e-05
Gc4_468 0 n8 ns468 0 -0.000106866187691
Gc4_469 0 n8 ns469 0 5.13685180801e-06
Gc4_470 0 n8 ns470 0 -0.000265784312762
Gc4_471 0 n8 ns471 0 -3.62698649796e-05
Gc4_472 0 n8 ns472 0 -7.24529960401e-05
Gc4_473 0 n8 ns473 0 -0.00037190542662
Gc4_474 0 n8 ns474 0 0.000334673208882
Gc4_475 0 n8 ns475 0 2.11294193444e-05
Gc4_476 0 n8 ns476 0 -1.10652504242e-05
Gc4_477 0 n8 ns477 0 9.74185865344e-05
Gc4_478 0 n8 ns478 0 -3.36946584439e-06
Gc4_479 0 n8 ns479 0 -0.000218440641882
Gc4_480 0 n8 ns480 0 0.000267059637625
Gc4_481 0 n8 ns481 0 -2.75814370456e-06
Gc4_482 0 n8 ns482 0 -3.34335372246e-06
Gc4_483 0 n8 ns483 0 1.25036055057e-05
Gc4_484 0 n8 ns484 0 1.82274964799e-06
Gc4_485 0 n8 ns485 0 0.000318476771031
Gc4_486 0 n8 ns486 0 -6.52462521575e-05
Gc4_487 0 n8 ns487 0 -1.91875194805e-05
Gc4_488 0 n8 ns488 0 9.19665046375e-06
Gc4_489 0 n8 ns489 0 1.24558789676e-05
Gc4_490 0 n8 ns490 0 8.03605978339e-05
Gc4_491 0 n8 ns491 0 0.000492655401846
Gc4_492 0 n8 ns492 0 -0.000757214618694
Gc4_493 0 n8 ns493 0 -0.000106785158688
Gc4_494 0 n8 ns494 0 8.90957870764e-05
Gc4_495 0 n8 ns495 0 2.46011476323e-06
Gc4_496 0 n8 ns496 0 1.20384122659e-07
Gc4_497 0 n8 ns497 0 -1.73291255347e-05
Gc4_498 0 n8 ns498 0 2.90718702265e-05
Gc4_499 0 n8 ns499 0 -2.77666788093e-06
Gc4_500 0 n8 ns500 0 -3.43064880928e-05
Gc4_501 0 n8 ns501 0 0.000108820541384
Gc4_502 0 n8 ns502 0 -4.48597540743e-05
Gc4_503 0 n8 ns503 0 -3.9071915202e-06
Gc4_504 0 n8 ns504 0 -0.000165086179702
Gc4_505 0 n8 ns505 0 0.000223993294973
Gc4_506 0 n8 ns506 0 3.72598207742e-05
Gc4_507 0 n8 ns507 0 1.88666311472e-05
Gc4_508 0 n8 ns508 0 -4.21612991098e-06
Gc4_509 0 n8 ns509 0 -2.37804693372e-06
Gc4_510 0 n8 ns510 0 4.6099731191e-05
Gc4_511 0 n8 ns511 0 0.000151785967119
Gc4_512 0 n8 ns512 0 -0.000143945081179
Gc4_513 0 n8 ns513 0 0.000247150176358
Gc4_514 0 n8 ns514 0 -0.000286884288493
Gc4_515 0 n8 ns515 0 5.9032327258e-07
Gc4_516 0 n8 ns516 0 7.25048238823e-06
Gc4_517 0 n8 ns517 0 4.07341279123e-05
Gc4_518 0 n8 ns518 0 8.49833036206e-06
Gc4_519 0 n8 ns519 0 4.28306945093e-07
Gc4_520 0 n8 ns520 0 2.70977572965e-07
Gc4_521 0 n8 ns521 0 0.000167764325715
Gc4_522 0 n8 ns522 0 -0.000306679571941
Gc4_523 0 n8 ns523 0 7.00992672418e-06
Gc4_524 0 n8 ns524 0 -6.67059314801e-05
Gc4_525 0 n8 ns525 0 6.26710114364e-06
Gc4_526 0 n8 ns526 0 -1.27609774048e-05
Gc4_527 0 n8 ns527 0 -5.91899734934e-05
Gc4_528 0 n8 ns528 0 8.45429168869e-05
Gc4_529 0 n8 ns529 0 0.000174056132528
Gc4_530 0 n8 ns530 0 6.43196718783e-05
Gc4_531 0 n8 ns531 0 -0.000491497415094
Gc4_532 0 n8 ns532 0 -0.00139154470448
Gc4_533 0 n8 ns533 0 -3.68175134287e-05
Gc4_534 0 n8 ns534 0 1.18388985503e-05
Gc4_535 0 n8 ns535 0 -0.0158390878156
Gc4_536 0 n8 ns536 0 0.0111264320006
Gc4_537 0 n8 ns537 0 0.00776828231708
Gc4_538 0 n8 ns538 0 0.00872547327348
Gc4_539 0 n8 ns539 0 -0.0139757633153
Gc4_540 0 n8 ns540 0 0.00010690670633
Gc4_541 0 n8 ns541 0 -2.00372388211e-05
Gc4_542 0 n8 ns542 0 1.29538340028e-05
Gc4_543 0 n8 ns543 0 -5.33241631499e-07
Gc4_544 0 n8 ns544 0 -2.66631585104e-07
Gc4_545 0 n8 ns545 0 -7.0380710606e-06
Gc4_546 0 n8 ns546 0 -9.00656405557e-06
Gc4_547 0 n8 ns547 0 -0.000292515892064
Gc4_548 0 n8 ns548 0 -0.000924939072323
Gc4_549 0 n8 ns549 0 3.98009453335e-10
Gc4_550 0 n8 ns550 0 -8.80064824584e-07
Gc4_551 0 n8 ns551 0 0.00265600172743
Gc4_552 0 n8 ns552 0 0.000686195341426
Gc4_553 0 n8 ns553 0 -1.9966818838e-05
Gc4_554 0 n8 ns554 0 1.09121819029e-05
Gc4_555 0 n8 ns555 0 -0.000298790792562
Gc4_556 0 n8 ns556 0 0.000100012167432
Gc4_557 0 n8 ns557 0 -0.00234164117064
Gc4_558 0 n8 ns558 0 -0.000469732471755
Gc4_559 0 n8 ns559 0 -0.00232541248672
Gc4_560 0 n8 ns560 0 0.00358526718356
Gc4_561 0 n8 ns561 0 6.17453344124e-05
Gc4_562 0 n8 ns562 0 8.74441330316e-06
Gc4_563 0 n8 ns563 0 -1.42632264275e-05
Gc4_564 0 n8 ns564 0 -2.40677970302e-06
Gc4_565 0 n8 ns565 0 -2.34129838638e-06
Gc4_566 0 n8 ns566 0 -3.61903250686e-05
Gc4_567 0 n8 ns567 0 0.000193384864052
Gc4_568 0 n8 ns568 0 0.000230210599404
Gc4_569 0 n8 ns569 0 -0.00101255714282
Gc4_570 0 n8 ns570 0 -0.00112017235688
Gc4_571 0 n8 ns571 0 5.2204523912e-05
Gc4_572 0 n8 ns572 0 -6.30379720545e-05
Gc4_573 0 n8 ns573 0 -1.90609952144e-05
Gc4_574 0 n8 ns574 0 2.98186439483e-06
Gc4_575 0 n8 ns575 0 -2.14284519112e-05
Gc4_576 0 n8 ns576 0 5.28736017592e-06
Gc4_577 0 n8 ns577 0 -4.41891793373e-06
Gc4_578 0 n8 ns578 0 2.05187953673e-05
Gc4_579 0 n8 ns579 0 -1.64234347103e-05
Gc4_580 0 n8 ns580 0 -1.11712932402e-05
Gc4_581 0 n8 ns581 0 4.24499581273e-05
Gc4_582 0 n8 ns582 0 2.40591897932e-05
Gc4_583 0 n8 ns583 0 1.29281642267e-05
Gc4_584 0 n8 ns584 0 -1.82003380421e-05
Gc4_585 0 n8 ns585 0 -3.02269832993e-05
Gc4_586 0 n8 ns586 0 4.42022688272e-06
Gc4_587 0 n8 ns587 0 8.83147102131e-08
Gc4_588 0 n8 ns588 0 -2.2993529856e-07
Gc4_589 0 n8 ns589 0 -1.09695755543e-05
Gc4_590 0 n8 ns590 0 -2.15005604053e-05
Gc4_591 0 n8 ns591 0 -2.38886943755e-06
Gc4_592 0 n8 ns592 0 -1.18641736566e-06
Gc4_593 0 n8 ns593 0 -5.79914213676e-07
Gc4_594 0 n8 ns594 0 -2.85676438878e-07
Gc4_595 0 n8 ns595 0 1.65687706825e-06
Gc4_596 0 n8 ns596 0 -2.01874055471e-06
Gc4_597 0 n8 ns597 0 1.4924227485e-06
Gc4_598 0 n8 ns598 0 2.44786868457e-06
Gc4_599 0 n8 ns599 0 1.07888094105e-06
Gc4_600 0 n8 ns600 0 7.37891828999e-07
Gc4_601 0 n8 ns601 0 -0.000497031577083
Gc4_602 0 n8 ns602 0 0.0021585287724
Gc4_603 0 n8 ns603 0 -0.000159092996484
Gc4_604 0 n8 ns604 0 0.000479369457862
Gc4_605 0 n8 ns605 0 -0.000107376267177
Gc4_606 0 n8 ns606 0 -6.29086811169e-05
Gc4_607 0 n8 ns607 0 3.83547643918e-05
Gc4_608 0 n8 ns608 0 -9.07590793702e-05
Gc4_609 0 n8 ns609 0 9.44636340545e-08
Gc4_610 0 n8 ns610 0 1.60202156863e-07
Gc4_611 0 n8 ns611 0 9.32752554678e-05
Gc4_612 0 n8 ns612 0 6.50670359957e-05
Gc4_613 0 n8 ns613 0 -2.98789021219e-05
Gc4_614 0 n8 ns614 0 4.14078727088e-05
Gc4_615 0 n8 ns615 0 2.40641662008e-05
Gc4_616 0 n8 ns616 0 9.84806864303e-05
Gc4_617 0 n8 ns617 0 -0.00020726543683
Gc4_618 0 n8 ns618 0 9.38825419818e-05
Gc4_619 0 n8 ns619 0 8.85464630586e-07
Gc4_620 0 n8 ns620 0 -0.000189547828906
Gc4_621 0 n8 ns621 0 -4.18109024932e-05
Gc4_622 0 n8 ns622 0 -5.63444413771e-05
Gc4_623 0 n8 ns623 0 0.00022646981653
Gc4_624 0 n8 ns624 0 0.000234479942483
Gc4_625 0 n8 ns625 0 9.63801542367e-06
Gc4_626 0 n8 ns626 0 -8.89929715462e-06
Gc4_627 0 n8 ns627 0 8.53355124444e-05
Gc4_628 0 n8 ns628 0 6.94533888088e-05
Gc4_629 0 n8 ns629 0 -0.000818755438581
Gc4_630 0 n8 ns630 0 8.79637089483e-05
Gc4_631 0 n8 ns631 0 -3.50431361841e-06
Gc4_632 0 n8 ns632 0 -4.95547982709e-07
Gc4_633 0 n8 ns633 0 -3.24430422736e-06
Gc4_634 0 n8 ns634 0 9.26687135962e-06
Gc4_635 0 n8 ns635 0 1.3924309525e-06
Gc4_636 0 n8 ns636 0 -0.000148034636308
Gc4_637 0 n8 ns637 0 1.21878039549e-06
Gc4_638 0 n8 ns638 0 -1.49751849301e-05
Gc4_639 0 n8 ns639 0 9.01498407253e-06
Gc4_640 0 n8 ns640 0 0.00011322870746
Gc4_641 0 n8 ns641 0 0.000283102285852
Gc4_642 0 n8 ns642 0 0.00120914001432
Gc4_643 0 n8 ns643 0 -7.3155171633e-05
Gc4_644 0 n8 ns644 0 -6.91293311677e-05
Gc4_645 0 n8 ns645 0 1.38605406442e-05
Gc4_646 0 n8 ns646 0 -8.72927008301e-06
Gc4_647 0 n8 ns647 0 -0.000144024943628
Gc4_648 0 n8 ns648 0 9.60627591052e-06
Gc4_649 0 n8 ns649 0 -4.50866445787e-05
Gc4_650 0 n8 ns650 0 2.74452436672e-05
Gc4_651 0 n8 ns651 0 -8.2931859557e-05
Gc4_652 0 n8 ns652 0 -8.7300722617e-05
Gc4_653 0 n8 ns653 0 1.45191094902e-05
Gc4_654 0 n8 ns654 0 -0.000168238988662
Gc4_655 0 n8 ns655 0 0.000573040390316
Gc4_656 0 n8 ns656 0 0.000524497034525
Gc4_657 0 n8 ns657 0 -3.02672118486e-05
Gc4_658 0 n8 ns658 0 1.97715719453e-05
Gc4_659 0 n8 ns659 0 -8.34845195576e-06
Gc4_660 0 n8 ns660 0 -3.52340834016e-05
Gc4_661 0 n8 ns661 0 -0.000159729590475
Gc4_662 0 n8 ns662 0 0.000128658396261
Gc4_663 0 n8 ns663 0 -0.000439592657607
Gc4_664 0 n8 ns664 0 0.00146327560383
Gc4_665 0 n8 ns665 0 -4.56522351336e-06
Gc4_666 0 n8 ns666 0 6.90870293296e-06
Gc4_667 0 n8 ns667 0 1.37362646955e-05
Gc4_668 0 n8 ns668 0 -2.18201798236e-05
Gc4_669 0 n8 ns669 0 4.61530749812e-08
Gc4_670 0 n8 ns670 0 -5.63226002464e-08
Gc4_671 0 n8 ns671 0 0.000536046820438
Gc4_672 0 n8 ns672 0 3.09942819221e-05
Gc4_673 0 n8 ns673 0 0.000368669184731
Gc4_674 0 n8 ns674 0 -0.000219505496634
Gc4_675 0 n8 ns675 0 1.33310944539e-05
Gc4_676 0 n8 ns676 0 3.12080881146e-06
Gc4_677 0 n8 ns677 0 -7.74900734573e-05
Gc4_678 0 n8 ns678 0 1.02112609249e-05
Gc4_679 0 n8 ns679 0 -3.56436367554e-05
Gc4_680 0 n8 ns680 0 0.000126340837261
Gc4_681 0 n8 ns681 0 0.000989857539531
Gc4_682 0 n8 ns682 0 0.00316973273951
Gc4_683 0 n8 ns683 0 3.97741918683e-05
Gc4_684 0 n8 ns684 0 -2.53258613651e-05
Gc4_685 0 n8 ns685 0 -0.0162760901093
Gc4_686 0 n8 ns686 0 -0.00186562804317
Gc4_687 0 n8 ns687 0 -0.00508942310624
Gc4_688 0 n8 ns688 0 0.00783225836677
Gc4_689 0 n8 ns689 0 -0.0128627114455
Gc4_690 0 n8 ns690 0 -2.36977540299e-05
Gc4_691 0 n8 ns691 0 3.32440302675e-05
Gc4_692 0 n8 ns692 0 1.93463355173e-05
Gc4_693 0 n8 ns693 0 4.60704996015e-07
Gc4_694 0 n8 ns694 0 -1.20934073653e-07
Gc4_695 0 n8 ns695 0 9.18299714266e-07
Gc4_696 0 n8 ns696 0 3.29634095703e-06
Gc4_697 0 n8 ns697 0 0.000477219988156
Gc4_698 0 n8 ns698 0 -0.000537429586118
Gc4_699 0 n8 ns699 0 9.36960420004e-08
Gc4_700 0 n8 ns700 0 -8.27207141785e-07
Gc4_701 0 n8 ns701 0 -0.00184581969675
Gc4_702 0 n8 ns702 0 -0.000344791733541
Gc4_703 0 n8 ns703 0 1.1855745901e-05
Gc4_704 0 n8 ns704 0 1.73231194791e-06
Gc4_705 0 n8 ns705 0 -0.000203270125924
Gc4_706 0 n8 ns706 0 4.42128848035e-06
Gc4_707 0 n8 ns707 0 0.00720615367119
Gc4_708 0 n8 ns708 0 0.00158775846373
Gc4_709 0 n8 ns709 0 0.00536648507028
Gc4_710 0 n8 ns710 0 -0.00584422844869
Gc4_711 0 n8 ns711 0 8.21557282022e-06
Gc4_712 0 n8 ns712 0 4.45087132868e-05
Gc4_713 0 n8 ns713 0 -1.36015055856e-05
Gc4_714 0 n8 ns714 0 -1.20255552338e-05
Gc4_715 0 n8 ns715 0 -5.27575962297e-06
Gc4_716 0 n8 ns716 0 -6.08020147412e-05
Gc4_717 0 n8 ns717 0 -0.000267747663235
Gc4_718 0 n8 ns718 0 -0.000144846563735
Gc4_719 0 n8 ns719 0 0.00150258258743
Gc4_720 0 n8 ns720 0 -0.00243732074656
Gc4_721 0 n8 ns721 0 -4.85608808136e-06
Gc4_722 0 n8 ns722 0 -7.09925577737e-05
Gc4_723 0 n8 ns723 0 1.11341424482e-05
Gc4_724 0 n8 ns724 0 -3.2260143553e-05
Gc4_725 0 n8 ns725 0 1.63382528719e-05
Gc4_726 0 n8 ns726 0 -1.88228842481e-05
Gc4_727 0 n8 ns727 0 5.20479429975e-06
Gc4_728 0 n8 ns728 0 -1.54137702309e-05
Gc4_729 0 n8 ns729 0 3.99387464047e-06
Gc4_730 0 n8 ns730 0 -1.89910077995e-05
Gc4_731 0 n8 ns731 0 -6.44929210905e-05
Gc4_732 0 n8 ns732 0 -2.10119888428e-05
Gc4_733 0 n8 ns733 0 -2.96265114233e-06
Gc4_734 0 n8 ns734 0 1.81899926494e-06
Gc4_735 0 n8 ns735 0 2.69702091998e-05
Gc4_736 0 n8 ns736 0 4.6312245315e-06
Gc4_737 0 n8 ns737 0 -4.43056544345e-07
Gc4_738 0 n8 ns738 0 -5.94713586358e-07
Gc4_739 0 n8 ns739 0 -2.93478970956e-06
Gc4_740 0 n8 ns740 0 1.85104751661e-05
Gc4_741 0 n8 ns741 0 -8.37548292989e-06
Gc4_742 0 n8 ns742 0 -1.14747303141e-09
Gc4_743 0 n8 ns743 0 -2.02248740246e-06
Gc4_744 0 n8 ns744 0 7.27737659003e-07
Gc4_745 0 n8 ns745 0 -4.13286813464e-06
Gc4_746 0 n8 ns746 0 -3.92322540062e-06
Gc4_747 0 n8 ns747 0 4.06654649474e-06
Gc4_748 0 n8 ns748 0 9.72996532597e-07
Gc4_749 0 n8 ns749 0 -4.78975361986e-07
Gc4_750 0 n8 ns750 0 5.77213508569e-07
Gc4_751 0 n8 ns751 0 0.000250997717849
Gc4_752 0 n8 ns752 0 -0.00181353696278
Gc4_753 0 n8 ns753 0 0.000738458354712
Gc4_754 0 n8 ns754 0 -6.14871588941e-05
Gc4_755 0 n8 ns755 0 -1.54290478841e-05
Gc4_756 0 n8 ns756 0 -6.97385381051e-05
Gc4_757 0 n8 ns757 0 -0.000111174611038
Gc4_758 0 n8 ns758 0 1.87775183209e-05
Gc4_759 0 n8 ns759 0 -1.56702445474e-08
Gc4_760 0 n8 ns760 0 2.03523131185e-08
Gc4_761 0 n8 ns761 0 2.76562758246e-05
Gc4_762 0 n8 ns762 0 2.30093515981e-05
Gc4_763 0 n8 ns763 0 5.82573265101e-05
Gc4_764 0 n8 ns764 0 3.06474943518e-05
Gc4_765 0 n8 ns765 0 0.000101413992719
Gc4_766 0 n8 ns766 0 -5.91125335879e-05
Gc4_767 0 n8 ns767 0 -3.97476302457e-05
Gc4_768 0 n8 ns768 0 -0.000178101365763
Gc4_769 0 n8 ns769 0 0.000162355136138
Gc4_770 0 n8 ns770 0 -1.60970556825e-05
Gc4_771 0 n8 ns771 0 1.05391533485e-05
Gc4_772 0 n8 ns772 0 -9.47936875292e-05
Gc4_773 0 n8 ns773 0 0.000295309853417
Gc4_774 0 n8 ns774 0 7.87696631691e-05
Gc4_775 0 n8 ns775 0 5.25803741952e-06
Gc4_776 0 n8 ns776 0 -2.38424142764e-05
Gc4_777 0 n8 ns777 0 0.000110430849483
Gc4_778 0 n8 ns778 0 -5.68358379472e-05
Gc4_779 0 n8 ns779 0 0.000220007351259
Gc4_780 0 n8 ns780 0 -0.000302208456021
Gc4_781 0 n8 ns781 0 -2.15499447404e-06
Gc4_782 0 n8 ns782 0 -1.90316571955e-06
Gc4_783 0 n8 ns783 0 6.48913475097e-06
Gc4_784 0 n8 ns784 0 -9.39473086968e-06
Gc4_785 0 n8 ns785 0 0.000127471970267
Gc4_786 0 n8 ns786 0 -0.000259876666588
Gc4_787 0 n8 ns787 0 -1.62381686672e-05
Gc4_788 0 n8 ns788 0 2.64545327456e-05
Gc4_789 0 n8 ns789 0 9.80871004081e-05
Gc4_790 0 n8 ns790 0 6.57258141874e-05
Gc4_791 0 n8 ns791 0 0.0008374463019
Gc4_792 0 n8 ns792 0 -0.00102084955203
Gc4_793 0 n8 ns793 0 -9.43422638178e-05
Gc4_794 0 n8 ns794 0 0.000207820451948
Gc4_795 0 n8 ns795 0 -4.52626425781e-06
Gc4_796 0 n8 ns796 0 1.55206415335e-06
Gc4_797 0 n8 ns797 0 5.86020427856e-05
Gc4_798 0 n8 ns798 0 -0.000135297479178
Gc4_799 0 n8 ns799 0 -2.32488306239e-05
Gc4_800 0 n8 ns800 0 -9.05846779372e-05
Gc4_801 0 n8 ns801 0 0.000193968906756
Gc4_802 0 n8 ns802 0 -0.000153759229288
Gc4_803 0 n8 ns803 0 -0.000172414961938
Gc4_804 0 n8 ns804 0 -0.000245772496524
Gc4_805 0 n8 ns805 0 5.74219776181e-05
Gc4_806 0 n8 ns806 0 -0.000820258273062
Gc4_807 0 n8 ns807 0 7.10618634945e-05
Gc4_808 0 n8 ns808 0 -7.68052469534e-06
Gc4_809 0 n8 ns809 0 5.05890690186e-05
Gc4_810 0 n8 ns810 0 4.58020750912e-05
Gc4_811 0 n8 ns811 0 3.81543096576e-05
Gc4_812 0 n8 ns812 0 -0.000305766169384
Gc4_813 0 n8 ns813 0 -0.00100458519597
Gc4_814 0 n8 ns814 0 -0.000550987949667
Gc4_815 0 n8 ns815 0 -8.99978907765e-06
Gc4_816 0 n8 ns816 0 6.73488083373e-07
Gc4_817 0 n8 ns817 0 2.53706579943e-05
Gc4_818 0 n8 ns818 0 -4.05902261499e-05
Gc4_819 0 n8 ns819 0 1.23488187527e-06
Gc4_820 0 n8 ns820 0 -4.5908920877e-07
Gc4_821 0 n8 ns821 0 -3.28742317898e-05
Gc4_822 0 n8 ns822 0 -0.00013417644274
Gc4_823 0 n8 ns823 0 -9.93589413816e-05
Gc4_824 0 n8 ns824 0 -0.000224362067156
Gc4_825 0 n8 ns825 0 7.93830333637e-06
Gc4_826 0 n8 ns826 0 -9.6806591179e-06
Gc4_827 0 n8 ns827 0 4.2320071918e-05
Gc4_828 0 n8 ns828 0 5.54515416646e-05
Gc4_829 0 n8 ns829 0 0.000127245227624
Gc4_830 0 n8 ns830 0 -8.44543513921e-05
Gc4_831 0 n8 ns831 0 -0.000703205298558
Gc4_832 0 n8 ns832 0 -0.00136952577369
Gc4_833 0 n8 ns833 0 -3.33636609824e-05
Gc4_834 0 n8 ns834 0 3.83662567385e-05
Gc4_835 0 n8 ns835 0 -0.0162465276329
Gc4_836 0 n8 ns836 0 0.0123805339537
Gc4_837 0 n8 ns837 0 0.00580324338142
Gc4_838 0 n8 ns838 0 0.00647756226978
Gc4_839 0 n8 ns839 0 -0.0148088703106
Gc4_840 0 n8 ns840 0 2.55123197622e-05
Gc4_841 0 n8 ns841 0 -2.94022055901e-05
Gc4_842 0 n8 ns842 0 2.92870275849e-05
Gc4_843 0 n8 ns843 0 8.83479830622e-08
Gc4_844 0 n8 ns844 0 6.96931936278e-08
Gc4_845 0 n8 ns845 0 -8.98010762368e-06
Gc4_846 0 n8 ns846 0 -1.16015201624e-05
Gc4_847 0 n8 ns847 0 8.20849481205e-05
Gc4_848 0 n8 ns848 0 -0.000901717777224
Gc4_849 0 n8 ns849 0 1.01491546296e-06
Gc4_850 0 n8 ns850 0 1.59061622762e-07
Gc4_851 0 n8 ns851 0 0.00214064638677
Gc4_852 0 n8 ns852 0 0.0003841271059
Gc4_853 0 n8 ns853 0 7.4940028949e-07
Gc4_854 0 n8 ns854 0 3.23481520918e-06
Gc4_855 0 n8 ns855 0 -0.00025971562961
Gc4_856 0 n8 ns856 0 0.000115670515817
Gc4_857 0 n8 ns857 0 -0.00315006082142
Gc4_858 0 n8 ns858 0 -0.000797560922734
Gc4_859 0 n8 ns859 0 -0.00433434951763
Gc4_860 0 n8 ns860 0 0.00317079942164
Gc4_861 0 n8 ns861 0 7.96838744457e-05
Gc4_862 0 n8 ns862 0 4.28162407909e-06
Gc4_863 0 n8 ns863 0 -1.54332765613e-05
Gc4_864 0 n8 ns864 0 6.73565698635e-06
Gc4_865 0 n8 ns865 0 -1.85539247168e-05
Gc4_866 0 n8 ns866 0 -3.79982938188e-05
Gc4_867 0 n8 ns867 0 0.00021519806297
Gc4_868 0 n8 ns868 0 0.000202893214377
Gc4_869 0 n8 ns869 0 -0.00122625905844
Gc4_870 0 n8 ns870 0 -0.00212702695006
Gc4_871 0 n8 ns871 0 2.9673483382e-05
Gc4_872 0 n8 ns872 0 -8.93545308867e-05
Gc4_873 0 n8 ns873 0 -1.71855498627e-05
Gc4_874 0 n8 ns874 0 6.96245470157e-06
Gc4_875 0 n8 ns875 0 -1.78323999089e-05
Gc4_876 0 n8 ns876 0 9.00169105508e-06
Gc4_877 0 n8 ns877 0 -4.27226459289e-07
Gc4_878 0 n8 ns878 0 2.66054336852e-05
Gc4_879 0 n8 ns879 0 -2.26453116421e-05
Gc4_880 0 n8 ns880 0 -1.89530592882e-06
Gc4_881 0 n8 ns881 0 2.97648828753e-05
Gc4_882 0 n8 ns882 0 1.72169030337e-05
Gc4_883 0 n8 ns883 0 6.46834712461e-06
Gc4_884 0 n8 ns884 0 -2.59245190453e-05
Gc4_885 0 n8 ns885 0 -3.39155818332e-05
Gc4_886 0 n8 ns886 0 1.72364895663e-05
Gc4_887 0 n8 ns887 0 2.34391868308e-07
Gc4_888 0 n8 ns888 0 4.9975287684e-08
Gc4_889 0 n8 ns889 0 5.30820400211e-06
Gc4_890 0 n8 ns890 0 -9.43723404569e-07
Gc4_891 0 n8 ns891 0 -3.62675238078e-06
Gc4_892 0 n8 ns892 0 3.46081349181e-06
Gc4_893 0 n8 ns893 0 -2.16733677457e-07
Gc4_894 0 n8 ns894 0 8.59769019672e-07
Gc4_895 0 n8 ns895 0 5.61995100847e-07
Gc4_896 0 n8 ns896 0 2.22380590727e-07
Gc4_897 0 n8 ns897 0 5.57299766334e-06
Gc4_898 0 n8 ns898 0 7.63288634899e-08
Gc4_899 0 n8 ns899 0 8.97989479103e-07
Gc4_900 0 n8 ns900 0 -8.82514703195e-07
Gd4_1 0 n8 ni1 0 0.000761602860772
Gd4_2 0 n8 ni2 0 0.00186470360157
Gd4_3 0 n8 ni3 0 -0.00025553865698
Gd4_4 0 n8 ni4 0 -0.00728172850367
Gd4_5 0 n8 ni5 0 0.000250549357052
Gd4_6 0 n8 ni6 0 0.00155155503623
Gc5_1 0 n10 ns1 0 0.000559226221957
Gc5_2 0 n10 ns2 0 0.000347046769425
Gc5_3 0 n10 ns3 0 0.000296997963658
Gc5_4 0 n10 ns4 0 -0.000138077474236
Gc5_5 0 n10 ns5 0 -2.49294902811e-05
Gc5_6 0 n10 ns6 0 2.47228746871e-05
Gc5_7 0 n10 ns7 0 0.000102873658554
Gc5_8 0 n10 ns8 0 -4.6972726671e-05
Gc5_9 0 n10 ns9 0 -9.15063955866e-09
Gc5_10 0 n10 ns10 0 1.62875452285e-08
Gc5_11 0 n10 ns11 0 -3.59424627178e-05
Gc5_12 0 n10 ns12 0 3.812251324e-05
Gc5_13 0 n10 ns13 0 2.09854044023e-05
Gc5_14 0 n10 ns14 0 -4.8635866757e-05
Gc5_15 0 n10 ns15 0 -4.19514164956e-05
Gc5_16 0 n10 ns16 0 -0.000145883015343
Gc5_17 0 n10 ns17 0 1.44152487978e-05
Gc5_18 0 n10 ns18 0 9.32656577383e-05
Gc5_19 0 n10 ns19 0 -0.00020598253131
Gc5_20 0 n10 ns20 0 -1.99501523965e-06
Gc5_21 0 n10 ns21 0 2.93342243837e-05
Gc5_22 0 n10 ns22 0 -9.89107914102e-05
Gc5_23 0 n10 ns23 0 -1.7030409533e-05
Gc5_24 0 n10 ns24 0 0.0003697127704
Gc5_25 0 n10 ns25 0 5.33937355463e-06
Gc5_26 0 n10 ns26 0 1.07035957701e-06
Gc5_27 0 n10 ns27 0 1.41891434954e-05
Gc5_28 0 n10 ns28 0 -3.81800296528e-05
Gc5_29 0 n10 ns29 0 0.000398198000374
Gc5_30 0 n10 ns30 0 -8.02621554433e-06
Gc5_31 0 n10 ns31 0 1.17789949752e-06
Gc5_32 0 n10 ns32 0 -1.84819243484e-06
Gc5_33 0 n10 ns33 0 -5.15988198029e-07
Gc5_34 0 n10 ns34 0 1.80517501555e-06
Gc5_35 0 n10 ns35 0 -0.00027667627998
Gc5_36 0 n10 ns36 0 -0.000346799570709
Gc5_37 0 n10 ns37 0 3.42293300659e-05
Gc5_38 0 n10 ns38 0 1.45047008052e-05
Gc5_39 0 n10 ns39 0 -7.83318987717e-05
Gc5_40 0 n10 ns40 0 3.39584054068e-05
Gc5_41 0 n10 ns41 0 -1.36885780442e-05
Gc5_42 0 n10 ns42 0 0.00047796362548
Gc5_43 0 n10 ns43 0 3.69854737055e-05
Gc5_44 0 n10 ns44 0 -4.48198525102e-05
Gc5_45 0 n10 ns45 0 1.02776297269e-05
Gc5_46 0 n10 ns46 0 -7.27960284954e-06
Gc5_47 0 n10 ns47 0 8.06916548722e-05
Gc5_48 0 n10 ns48 0 -0.00014182536775
Gc5_49 0 n10 ns49 0 5.01932331845e-05
Gc5_50 0 n10 ns50 0 -8.60246649579e-06
Gc5_51 0 n10 ns51 0 -1.11542374723e-05
Gc5_52 0 n10 ns52 0 8.86696458833e-05
Gc5_53 0 n10 ns53 0 -7.08648466023e-05
Gc5_54 0 n10 ns54 0 9.38985509745e-05
Gc5_55 0 n10 ns55 0 0.000253601434762
Gc5_56 0 n10 ns56 0 8.53317483625e-05
Gc5_57 0 n10 ns57 0 1.85681981786e-05
Gc5_58 0 n10 ns58 0 -1.11769020062e-05
Gc5_59 0 n10 ns59 0 -3.39304967036e-05
Gc5_60 0 n10 ns60 0 -1.03539679848e-07
Gc5_61 0 n10 ns61 0 9.72213452035e-05
Gc5_62 0 n10 ns62 0 0.000127298588125
Gc5_63 0 n10 ns63 0 0.000363846434344
Gc5_64 0 n10 ns64 0 -0.000233815169923
Gc5_65 0 n10 ns65 0 7.22471784102e-06
Gc5_66 0 n10 ns66 0 9.49374549544e-10
Gc5_67 0 n10 ns67 0 3.2715828028e-05
Gc5_68 0 n10 ns68 0 -5.16029418047e-05
Gc5_69 0 n10 ns69 0 3.49879810801e-07
Gc5_70 0 n10 ns70 0 2.97561626605e-07
Gc5_71 0 n10 ns71 0 0.000203460695487
Gc5_72 0 n10 ns72 0 5.59420984916e-05
Gc5_73 0 n10 ns73 0 0.000257241113482
Gc5_74 0 n10 ns74 0 -6.49360119231e-05
Gc5_75 0 n10 ns75 0 8.50265149839e-06
Gc5_76 0 n10 ns76 0 1.00245125838e-05
Gc5_77 0 n10 ns77 0 2.41162388391e-05
Gc5_78 0 n10 ns78 0 5.15626254988e-05
Gc5_79 0 n10 ns79 0 0.000125927057401
Gc5_80 0 n10 ns80 0 -3.64876150711e-05
Gc5_81 0 n10 ns81 0 0.000312255689342
Gc5_82 0 n10 ns82 0 -0.00141086926419
Gc5_83 0 n10 ns83 0 -2.96400704986e-05
Gc5_84 0 n10 ns84 0 1.82654287867e-05
Gc5_85 0 n10 ns85 0 -0.00216075174713
Gc5_86 0 n10 ns86 0 0.00665046500296
Gc5_87 0 n10 ns87 0 0.00253040699045
Gc5_88 0 n10 ns88 0 -0.000323625148799
Gc5_89 0 n10 ns89 0 -0.00663420241078
Gc5_90 0 n10 ns90 0 -7.13674232453e-07
Gc5_91 0 n10 ns91 0 -1.15720826811e-05
Gc5_92 0 n10 ns92 0 -2.61983640532e-05
Gc5_93 0 n10 ns93 0 -2.39708246127e-07
Gc5_94 0 n10 ns94 0 -6.62159210404e-08
Gc5_95 0 n10 ns95 0 -5.38010202828e-06
Gc5_96 0 n10 ns96 0 -3.1150657178e-06
Gc5_97 0 n10 ns97 0 5.93287457118e-05
Gc5_98 0 n10 ns98 0 -0.00110807002104
Gc5_99 0 n10 ns99 0 -4.0781046423e-07
Gc5_100 0 n10 ns100 0 9.44231865927e-07
Gc5_101 0 n10 ns101 0 0.00202535566826
Gc5_102 0 n10 ns102 0 -0.00100248688721
Gc5_103 0 n10 ns103 0 -9.53794334503e-06
Gc5_104 0 n10 ns104 0 4.13892074239e-05
Gc5_105 0 n10 ns105 0 -0.000238426892107
Gc5_106 0 n10 ns106 0 7.87825890606e-05
Gc5_107 0 n10 ns107 0 -0.00213448726789
Gc5_108 0 n10 ns108 0 -6.83578229918e-05
Gc5_109 0 n10 ns109 0 0.000317127865649
Gc5_110 0 n10 ns110 0 0.00444730493782
Gc5_111 0 n10 ns111 0 -2.12439640229e-05
Gc5_112 0 n10 ns112 0 -4.11525389322e-05
Gc5_113 0 n10 ns113 0 -4.28900937728e-06
Gc5_114 0 n10 ns114 0 -7.17938819182e-06
Gc5_115 0 n10 ns115 0 -1.16091678458e-05
Gc5_116 0 n10 ns116 0 -3.04271436271e-05
Gc5_117 0 n10 ns117 0 5.78751840039e-05
Gc5_118 0 n10 ns118 0 4.30702948715e-05
Gc5_119 0 n10 ns119 0 -0.00178693052907
Gc5_120 0 n10 ns120 0 -0.00120993774579
Gc5_121 0 n10 ns121 0 -4.01487284298e-05
Gc5_122 0 n10 ns122 0 5.5653108328e-05
Gc5_123 0 n10 ns123 0 2.44807163493e-05
Gc5_124 0 n10 ns124 0 -2.45828076663e-05
Gc5_125 0 n10 ns125 0 -4.2638409949e-06
Gc5_126 0 n10 ns126 0 7.42648629898e-06
Gc5_127 0 n10 ns127 0 9.45280054286e-06
Gc5_128 0 n10 ns128 0 7.68126366307e-06
Gc5_129 0 n10 ns129 0 4.61451320421e-05
Gc5_130 0 n10 ns130 0 8.76537557082e-06
Gc5_131 0 n10 ns131 0 7.27190975603e-05
Gc5_132 0 n10 ns132 0 3.64525819823e-06
Gc5_133 0 n10 ns133 0 1.83802527502e-05
Gc5_134 0 n10 ns134 0 5.80521884187e-06
Gc5_135 0 n10 ns135 0 -1.40097374172e-05
Gc5_136 0 n10 ns136 0 8.40026643132e-06
Gc5_137 0 n10 ns137 0 -7.8517195374e-07
Gc5_138 0 n10 ns138 0 -1.18638227279e-06
Gc5_139 0 n10 ns139 0 3.91010971277e-06
Gc5_140 0 n10 ns140 0 -2.71474003536e-05
Gc5_141 0 n10 ns141 0 -6.64681777424e-07
Gc5_142 0 n10 ns142 0 2.23051772824e-07
Gc5_143 0 n10 ns143 0 -3.85290618885e-07
Gc5_144 0 n10 ns144 0 4.86620754023e-07
Gc5_145 0 n10 ns145 0 -5.63726648411e-07
Gc5_146 0 n10 ns146 0 -3.85771487339e-07
Gc5_147 0 n10 ns147 0 -1.13987859296e-06
Gc5_148 0 n10 ns148 0 6.55537322383e-07
Gc5_149 0 n10 ns149 0 9.77005339416e-07
Gc5_150 0 n10 ns150 0 1.35984168363e-06
Gc5_151 0 n10 ns151 0 -0.000791358003629
Gc5_152 0 n10 ns152 0 -0.000269183276733
Gc5_153 0 n10 ns153 0 0.000294171991338
Gc5_154 0 n10 ns154 0 -0.000210130316467
Gc5_155 0 n10 ns155 0 0.000180969473016
Gc5_156 0 n10 ns156 0 0.000339598323236
Gc5_157 0 n10 ns157 0 -0.000170867691447
Gc5_158 0 n10 ns158 0 -0.000188723708232
Gc5_159 0 n10 ns159 0 4.95213310961e-08
Gc5_160 0 n10 ns160 0 2.59145042697e-08
Gc5_161 0 n10 ns161 0 2.79606484003e-06
Gc5_162 0 n10 ns162 0 -0.000291274590906
Gc5_163 0 n10 ns163 0 0.000120515070651
Gc5_164 0 n10 ns164 0 5.78748272934e-06
Gc5_165 0 n10 ns165 0 0.000140818820022
Gc5_166 0 n10 ns166 0 -0.000129556573435
Gc5_167 0 n10 ns167 0 1.63265869738e-05
Gc5_168 0 n10 ns168 0 0.000214224893295
Gc5_169 0 n10 ns169 0 -0.000343167520737
Gc5_170 0 n10 ns170 0 3.5599857147e-05
Gc5_171 0 n10 ns171 0 -4.31513919237e-05
Gc5_172 0 n10 ns172 0 7.52249737056e-05
Gc5_173 0 n10 ns173 0 8.99338998655e-05
Gc5_174 0 n10 ns174 0 -0.00075113075808
Gc5_175 0 n10 ns175 0 -1.16426514828e-07
Gc5_176 0 n10 ns176 0 -1.90033285935e-06
Gc5_177 0 n10 ns177 0 0.00016186658521
Gc5_178 0 n10 ns178 0 2.15547044796e-06
Gc5_179 0 n10 ns179 0 -0.000403024168992
Gc5_180 0 n10 ns180 0 0.000692514110321
Gc5_181 0 n10 ns181 0 2.63591675942e-06
Gc5_182 0 n10 ns182 0 1.12784229121e-06
Gc5_183 0 n10 ns183 0 9.0237225506e-07
Gc5_184 0 n10 ns184 0 1.48771674499e-05
Gc5_185 0 n10 ns185 0 -0.000605410935945
Gc5_186 0 n10 ns186 0 -0.000295759589644
Gc5_187 0 n10 ns187 0 2.86546492162e-05
Gc5_188 0 n10 ns188 0 2.21261954569e-07
Gc5_189 0 n10 ns189 0 1.43504490779e-05
Gc5_190 0 n10 ns190 0 6.35310871857e-05
Gc5_191 0 n10 ns191 0 0.0010141453863
Gc5_192 0 n10 ns192 0 0.000124965681781
Gc5_193 0 n10 ns193 0 -0.000138060410554
Gc5_194 0 n10 ns194 0 5.73014508786e-05
Gc5_195 0 n10 ns195 0 6.64164282835e-06
Gc5_196 0 n10 ns196 0 -4.48503539947e-06
Gc5_197 0 n10 ns197 0 -0.000138073294674
Gc5_198 0 n10 ns198 0 0.000163565054673
Gc5_199 0 n10 ns199 0 -2.9158816e-05
Gc5_200 0 n10 ns200 0 5.52077609294e-05
Gc5_201 0 n10 ns201 0 -0.000250967056572
Gc5_202 0 n10 ns202 0 -8.10419125162e-05
Gc5_203 0 n10 ns203 0 -0.00021642226495
Gc5_204 0 n10 ns204 0 -0.000215484517879
Gc5_205 0 n10 ns205 0 0.000311336185592
Gc5_206 0 n10 ns206 0 -0.000251521133811
Gc5_207 0 n10 ns207 0 3.02326158292e-06
Gc5_208 0 n10 ns208 0 2.13677180996e-05
Gc5_209 0 n10 ns209 0 1.2332437071e-05
Gc5_210 0 n10 ns210 0 3.06084688637e-07
Gc5_211 0 n10 ns211 0 -6.12909628461e-05
Gc5_212 0 n10 ns212 0 -1.47944209629e-05
Gc5_213 0 n10 ns213 0 0.000115666880784
Gc5_214 0 n10 ns214 0 0.0012804419801
Gc5_215 0 n10 ns215 0 2.57552305465e-07
Gc5_216 0 n10 ns216 0 8.51678864709e-06
Gc5_217 0 n10 ns217 0 2.50879280905e-05
Gc5_218 0 n10 ns218 0 1.07460909834e-05
Gc5_219 0 n10 ns219 0 -1.34704082759e-07
Gc5_220 0 n10 ns220 0 2.13004758959e-07
Gc5_221 0 n10 ns221 0 0.000208001778645
Gc5_222 0 n10 ns222 0 -0.00055904810616
Gc5_223 0 n10 ns223 0 -0.00014387024226
Gc5_224 0 n10 ns224 0 -0.000331146703192
Gc5_225 0 n10 ns225 0 1.24663885152e-05
Gc5_226 0 n10 ns226 0 2.17084415685e-06
Gc5_227 0 n10 ns227 0 -1.56025852432e-05
Gc5_228 0 n10 ns228 0 -7.72817140422e-06
Gc5_229 0 n10 ns229 0 -4.35207815557e-05
Gc5_230 0 n10 ns230 0 2.71779773314e-05
Gc5_231 0 n10 ns231 0 0.00110193349152
Gc5_232 0 n10 ns232 0 0.00129979978269
Gc5_233 0 n10 ns233 0 2.78383866905e-05
Gc5_234 0 n10 ns234 0 -1.45073171851e-05
Gc5_235 0 n10 ns235 0 -0.0145001958546
Gc5_236 0 n10 ns236 0 0.00275676188157
Gc5_237 0 n10 ns237 0 -0.00315696048227
Gc5_238 0 n10 ns238 0 0.00277739473462
Gc5_239 0 n10 ns239 0 -0.0106995587738
Gc5_240 0 n10 ns240 0 3.56073577891e-06
Gc5_241 0 n10 ns241 0 2.83229887295e-05
Gc5_242 0 n10 ns242 0 1.59912045835e-05
Gc5_243 0 n10 ns243 0 1.87664318482e-07
Gc5_244 0 n10 ns244 0 -1.40433816916e-07
Gc5_245 0 n10 ns245 0 -8.46089552786e-07
Gc5_246 0 n10 ns246 0 7.25449064645e-06
Gc5_247 0 n10 ns247 0 4.49015491182e-05
Gc5_248 0 n10 ns248 0 -0.000442701868848
Gc5_249 0 n10 ns249 0 2.22217875755e-07
Gc5_250 0 n10 ns250 0 -1.53796235216e-06
Gc5_251 0 n10 ns251 0 -0.00174215894315
Gc5_252 0 n10 ns252 0 -0.000389113528277
Gc5_253 0 n10 ns253 0 1.85256560679e-05
Gc5_254 0 n10 ns254 0 6.83980226954e-06
Gc5_255 0 n10 ns255 0 -0.000208655939855
Gc5_256 0 n10 ns256 0 1.0912259759e-05
Gc5_257 0 n10 ns257 0 0.00322344770824
Gc5_258 0 n10 ns258 0 -0.00115190085505
Gc5_259 0 n10 ns259 0 -0.000252011491228
Gc5_260 0 n10 ns260 0 -0.00468645958131
Gc5_261 0 n10 ns261 0 -7.89564259377e-06
Gc5_262 0 n10 ns262 0 3.46823477064e-05
Gc5_263 0 n10 ns263 0 -1.25534034063e-05
Gc5_264 0 n10 ns264 0 -7.81608171424e-06
Gc5_265 0 n10 ns265 0 2.37093474221e-05
Gc5_266 0 n10 ns266 0 -5.52272836478e-05
Gc5_267 0 n10 ns267 0 -0.000152431514307
Gc5_268 0 n10 ns268 0 -0.000139877976628
Gc5_269 0 n10 ns269 0 0.000333380636412
Gc5_270 0 n10 ns270 0 -0.00216097073315
Gc5_271 0 n10 ns271 0 -1.37212882899e-05
Gc5_272 0 n10 ns272 0 -6.77359157635e-05
Gc5_273 0 n10 ns273 0 8.45772500813e-06
Gc5_274 0 n10 ns274 0 -2.32661294977e-05
Gc5_275 0 n10 ns275 0 1.26563187367e-05
Gc5_276 0 n10 ns276 0 -1.17145750135e-05
Gc5_277 0 n10 ns277 0 1.87461913207e-06
Gc5_278 0 n10 ns278 0 -1.62275026516e-05
Gc5_279 0 n10 ns279 0 4.32818697243e-06
Gc5_280 0 n10 ns280 0 -1.94327533136e-05
Gc5_281 0 n10 ns281 0 -5.76873018464e-05
Gc5_282 0 n10 ns282 0 -2.93392009897e-05
Gc5_283 0 n10 ns283 0 -2.76395446622e-06
Gc5_284 0 n10 ns284 0 3.06923939624e-06
Gc5_285 0 n10 ns285 0 2.37193961493e-05
Gc5_286 0 n10 ns286 0 4.41292799133e-06
Gc5_287 0 n10 ns287 0 -4.23702943999e-07
Gc5_288 0 n10 ns288 0 -2.30831126047e-07
Gc5_289 0 n10 ns289 0 6.75040967013e-06
Gc5_290 0 n10 ns290 0 2.40616929519e-05
Gc5_291 0 n10 ns291 0 -5.7070828135e-06
Gc5_292 0 n10 ns292 0 1.3978943337e-06
Gc5_293 0 n10 ns293 0 -1.26140785106e-06
Gc5_294 0 n10 ns294 0 7.02860222619e-07
Gc5_295 0 n10 ns295 0 -2.69079627489e-06
Gc5_296 0 n10 ns296 0 -1.86696651157e-06
Gc5_297 0 n10 ns297 0 4.30940236144e-06
Gc5_298 0 n10 ns298 0 -1.59361370787e-06
Gc5_299 0 n10 ns299 0 -6.80128933334e-07
Gc5_300 0 n10 ns300 0 -6.7512014466e-07
Gc5_301 0 n10 ns301 0 -0.000232049448291
Gc5_302 0 n10 ns302 0 -0.000972898754448
Gc5_303 0 n10 ns303 0 0.00103328535719
Gc5_304 0 n10 ns304 0 -0.00044534858034
Gc5_305 0 n10 ns305 0 -9.95901334516e-05
Gc5_306 0 n10 ns306 0 4.16098462586e-05
Gc5_307 0 n10 ns307 0 0.000184547055193
Gc5_308 0 n10 ns308 0 -0.000108561948099
Gc5_309 0 n10 ns309 0 -2.14441298302e-08
Gc5_310 0 n10 ns310 0 -5.06215206808e-08
Gc5_311 0 n10 ns311 0 1.4300328383e-05
Gc5_312 0 n10 ns312 0 -4.33491956948e-05
Gc5_313 0 n10 ns313 0 2.68592936684e-05
Gc5_314 0 n10 ns314 0 -5.7901044395e-05
Gc5_315 0 n10 ns315 0 -0.000151951027979
Gc5_316 0 n10 ns316 0 -9.27357885852e-05
Gc5_317 0 n10 ns317 0 3.61478857181e-05
Gc5_318 0 n10 ns318 0 -2.45135956973e-05
Gc5_319 0 n10 ns319 0 -0.000112721622584
Gc5_320 0 n10 ns320 0 7.55443787047e-05
Gc5_321 0 n10 ns321 0 9.06306265866e-05
Gc5_322 0 n10 ns322 0 -2.77137329244e-05
Gc5_323 0 n10 ns323 0 0.000125339445649
Gc5_324 0 n10 ns324 0 -0.00011935988845
Gc5_325 0 n10 ns325 0 2.45190050596e-06
Gc5_326 0 n10 ns326 0 -2.60359655498e-06
Gc5_327 0 n10 ns327 0 7.93517554373e-05
Gc5_328 0 n10 ns328 0 4.68872100609e-05
Gc5_329 0 n10 ns329 0 6.04030749368e-05
Gc5_330 0 n10 ns330 0 -0.000529896098119
Gc5_331 0 n10 ns331 0 -1.72811716818e-06
Gc5_332 0 n10 ns332 0 -8.47186429344e-07
Gc5_333 0 n10 ns333 0 1.07560037499e-06
Gc5_334 0 n10 ns334 0 3.95582932735e-06
Gc5_335 0 n10 ns335 0 -0.000191672834257
Gc5_336 0 n10 ns336 0 -6.26619524361e-05
Gc5_337 0 n10 ns337 0 3.04409996708e-05
Gc5_338 0 n10 ns338 0 1.14715523774e-05
Gc5_339 0 n10 ns339 0 -0.000120447360138
Gc5_340 0 n10 ns340 0 -6.80039814395e-05
Gc5_341 0 n10 ns341 0 0.000107266022326
Gc5_342 0 n10 ns342 0 6.04616169374e-05
Gc5_343 0 n10 ns343 0 5.17947032161e-05
Gc5_344 0 n10 ns344 0 -1.99881863876e-05
Gc5_345 0 n10 ns345 0 9.40144654878e-06
Gc5_346 0 n10 ns346 0 -4.90525978918e-06
Gc5_347 0 n10 ns347 0 5.90941170176e-05
Gc5_348 0 n10 ns348 0 -0.000190841283886
Gc5_349 0 n10 ns349 0 2.29865494098e-05
Gc5_350 0 n10 ns350 0 8.04775789942e-06
Gc5_351 0 n10 ns351 0 -0.000106336304906
Gc5_352 0 n10 ns352 0 -7.39064963287e-05
Gc5_353 0 n10 ns353 0 -7.60701779596e-05
Gc5_354 0 n10 ns354 0 -0.000149622344201
Gc5_355 0 n10 ns355 0 0.000408764432869
Gc5_356 0 n10 ns356 0 0.000236724035024
Gc5_357 0 n10 ns357 0 2.1910228498e-05
Gc5_358 0 n10 ns358 0 9.63572349927e-06
Gc5_359 0 n10 ns359 0 -1.37618029065e-05
Gc5_360 0 n10 ns360 0 1.13659093753e-06
Gc5_361 0 n10 ns361 0 7.72818888391e-05
Gc5_362 0 n10 ns362 0 4.65380427009e-05
Gc5_363 0 n10 ns363 0 0.000197987873418
Gc5_364 0 n10 ns364 0 -0.00128260760709
Gc5_365 0 n10 ns365 0 3.89905474064e-06
Gc5_366 0 n10 ns366 0 3.26743455465e-06
Gc5_367 0 n10 ns367 0 3.12602838002e-05
Gc5_368 0 n10 ns368 0 -4.61513071112e-05
Gc5_369 0 n10 ns369 0 2.27132511865e-07
Gc5_370 0 n10 ns370 0 4.16188331435e-07
Gc5_371 0 n10 ns371 0 -0.000114483131579
Gc5_372 0 n10 ns372 0 -0.000810414406331
Gc5_373 0 n10 ns373 0 -0.000348611679746
Gc5_374 0 n10 ns374 0 -8.07571856272e-05
Gc5_375 0 n10 ns375 0 1.33154934908e-05
Gc5_376 0 n10 ns376 0 -6.88645603258e-06
Gc5_377 0 n10 ns377 0 7.19595519599e-06
Gc5_378 0 n10 ns378 0 -1.1785325317e-05
Gc5_379 0 n10 ns379 0 5.45508928291e-05
Gc5_380 0 n10 ns380 0 -3.06911494839e-06
Gc5_381 0 n10 ns381 0 -0.000439100670067
Gc5_382 0 n10 ns382 0 -0.000665695611274
Gc5_383 0 n10 ns383 0 -2.66544312967e-05
Gc5_384 0 n10 ns384 0 3.17192276588e-05
Gc5_385 0 n10 ns385 0 -0.014627037104
Gc5_386 0 n10 ns386 0 0.0113650816879
Gc5_387 0 n10 ns387 0 0.00542349829163
Gc5_388 0 n10 ns388 0 0.00489001234558
Gc5_389 0 n10 ns389 0 -0.0141622173663
Gc5_390 0 n10 ns390 0 2.56235756068e-05
Gc5_391 0 n10 ns391 0 -1.56664902541e-05
Gc5_392 0 n10 ns392 0 -2.34864814736e-05
Gc5_393 0 n10 ns393 0 1.06793870677e-07
Gc5_394 0 n10 ns394 0 -2.37078353085e-08
Gc5_395 0 n10 ns395 0 -6.47653816777e-06
Gc5_396 0 n10 ns396 0 -5.87803881556e-06
Gc5_397 0 n10 ns397 0 0.000259228588519
Gc5_398 0 n10 ns398 0 -0.00115866035447
Gc5_399 0 n10 ns399 0 2.68225367507e-07
Gc5_400 0 n10 ns400 0 1.39629875826e-06
Gc5_401 0 n10 ns401 0 0.0026792131725
Gc5_402 0 n10 ns402 0 0.000157859814454
Gc5_403 0 n10 ns403 0 -1.1750636572e-05
Gc5_404 0 n10 ns404 0 2.65310937231e-05
Gc5_405 0 n10 ns405 0 -0.00029015093431
Gc5_406 0 n10 ns406 0 7.50907010951e-05
Gc5_407 0 n10 ns407 0 -0.00277483189527
Gc5_408 0 n10 ns408 0 -0.000611216527437
Gc5_409 0 n10 ns409 0 -0.00450272586449
Gc5_410 0 n10 ns410 0 0.00322131872137
Gc5_411 0 n10 ns411 0 -3.50896078595e-05
Gc5_412 0 n10 ns412 0 -5.08145701458e-05
Gc5_413 0 n10 ns413 0 -8.5932750081e-06
Gc5_414 0 n10 ns414 0 -7.18428052332e-06
Gc5_415 0 n10 ns415 0 3.88245918667e-06
Gc5_416 0 n10 ns416 0 -3.81189866935e-05
Gc5_417 0 n10 ns417 0 0.000196024533158
Gc5_418 0 n10 ns418 0 -1.85184422914e-06
Gc5_419 0 n10 ns419 0 -0.000371640742678
Gc5_420 0 n10 ns420 0 -0.00246223335336
Gc5_421 0 n10 ns421 0 -3.98966420667e-05
Gc5_422 0 n10 ns422 0 3.4591364708e-05
Gc5_423 0 n10 ns423 0 3.03838625642e-05
Gc5_424 0 n10 ns424 0 -1.79662007365e-06
Gc5_425 0 n10 ns425 0 5.22712788654e-06
Gc5_426 0 n10 ns426 0 2.52538467618e-05
Gc5_427 0 n10 ns427 0 5.73202273564e-06
Gc5_428 0 n10 ns428 0 2.48574047766e-05
Gc5_429 0 n10 ns429 0 2.85814881977e-05
Gc5_430 0 n10 ns430 0 1.98318425282e-05
Gc5_431 0 n10 ns431 0 4.02346071686e-05
Gc5_432 0 n10 ns432 0 -9.24623623362e-06
Gc5_433 0 n10 ns433 0 1.57472598025e-05
Gc5_434 0 n10 ns434 0 -8.30922855714e-06
Gc5_435 0 n10 ns435 0 -3.06308131737e-05
Gc5_436 0 n10 ns436 0 1.78801975622e-05
Gc5_437 0 n10 ns437 0 4.49936313544e-07
Gc5_438 0 n10 ns438 0 -7.25382070564e-07
Gc5_439 0 n10 ns439 0 3.30438343879e-05
Gc5_440 0 n10 ns440 0 -3.28271171253e-06
Gc5_441 0 n10 ns441 0 -3.88411884148e-06
Gc5_442 0 n10 ns442 0 1.99426453194e-06
Gc5_443 0 n10 ns443 0 -6.75719290379e-07
Gc5_444 0 n10 ns444 0 1.30425807086e-06
Gc5_445 0 n10 ns445 0 -2.03114265887e-06
Gc5_446 0 n10 ns446 0 1.09072068228e-07
Gc5_447 0 n10 ns447 0 -5.47657546793e-08
Gc5_448 0 n10 ns448 0 -5.69955096006e-08
Gc5_449 0 n10 ns449 0 -1.23669371558e-06
Gc5_450 0 n10 ns450 0 -2.51158782767e-07
Gc5_451 0 n10 ns451 0 -0.000497031577083
Gc5_452 0 n10 ns452 0 0.0021585287724
Gc5_453 0 n10 ns453 0 -0.000159092996484
Gc5_454 0 n10 ns454 0 0.000479369457862
Gc5_455 0 n10 ns455 0 -0.000107376267177
Gc5_456 0 n10 ns456 0 -6.29086811169e-05
Gc5_457 0 n10 ns457 0 3.83547643918e-05
Gc5_458 0 n10 ns458 0 -9.07590793702e-05
Gc5_459 0 n10 ns459 0 9.44636340545e-08
Gc5_460 0 n10 ns460 0 1.60202156863e-07
Gc5_461 0 n10 ns461 0 9.32752554678e-05
Gc5_462 0 n10 ns462 0 6.50670359957e-05
Gc5_463 0 n10 ns463 0 -2.98789021219e-05
Gc5_464 0 n10 ns464 0 4.14078727088e-05
Gc5_465 0 n10 ns465 0 2.40641662008e-05
Gc5_466 0 n10 ns466 0 9.84806864303e-05
Gc5_467 0 n10 ns467 0 -0.00020726543683
Gc5_468 0 n10 ns468 0 9.38825419818e-05
Gc5_469 0 n10 ns469 0 8.85464630586e-07
Gc5_470 0 n10 ns470 0 -0.000189547828906
Gc5_471 0 n10 ns471 0 -4.18109024932e-05
Gc5_472 0 n10 ns472 0 -5.63444413771e-05
Gc5_473 0 n10 ns473 0 0.00022646981653
Gc5_474 0 n10 ns474 0 0.000234479942483
Gc5_475 0 n10 ns475 0 9.63801542367e-06
Gc5_476 0 n10 ns476 0 -8.89929715462e-06
Gc5_477 0 n10 ns477 0 8.53355124444e-05
Gc5_478 0 n10 ns478 0 6.94533888088e-05
Gc5_479 0 n10 ns479 0 -0.000818755438581
Gc5_480 0 n10 ns480 0 8.79637089483e-05
Gc5_481 0 n10 ns481 0 -3.50431361841e-06
Gc5_482 0 n10 ns482 0 -4.95547982709e-07
Gc5_483 0 n10 ns483 0 -3.24430422736e-06
Gc5_484 0 n10 ns484 0 9.26687135962e-06
Gc5_485 0 n10 ns485 0 1.3924309525e-06
Gc5_486 0 n10 ns486 0 -0.000148034636308
Gc5_487 0 n10 ns487 0 1.21878039549e-06
Gc5_488 0 n10 ns488 0 -1.49751849301e-05
Gc5_489 0 n10 ns489 0 9.01498407253e-06
Gc5_490 0 n10 ns490 0 0.00011322870746
Gc5_491 0 n10 ns491 0 0.000283102285852
Gc5_492 0 n10 ns492 0 0.00120914001432
Gc5_493 0 n10 ns493 0 -7.3155171633e-05
Gc5_494 0 n10 ns494 0 -6.91293311677e-05
Gc5_495 0 n10 ns495 0 1.38605406442e-05
Gc5_496 0 n10 ns496 0 -8.72927008301e-06
Gc5_497 0 n10 ns497 0 -0.000144024943628
Gc5_498 0 n10 ns498 0 9.60627591052e-06
Gc5_499 0 n10 ns499 0 -4.50866445787e-05
Gc5_500 0 n10 ns500 0 2.74452436672e-05
Gc5_501 0 n10 ns501 0 -8.2931859557e-05
Gc5_502 0 n10 ns502 0 -8.7300722617e-05
Gc5_503 0 n10 ns503 0 1.45191094902e-05
Gc5_504 0 n10 ns504 0 -0.000168238988662
Gc5_505 0 n10 ns505 0 0.000573040390316
Gc5_506 0 n10 ns506 0 0.000524497034525
Gc5_507 0 n10 ns507 0 -3.02672118486e-05
Gc5_508 0 n10 ns508 0 1.97715719453e-05
Gc5_509 0 n10 ns509 0 -8.34845195576e-06
Gc5_510 0 n10 ns510 0 -3.52340834016e-05
Gc5_511 0 n10 ns511 0 -0.000159729590475
Gc5_512 0 n10 ns512 0 0.000128658396261
Gc5_513 0 n10 ns513 0 -0.000439592657607
Gc5_514 0 n10 ns514 0 0.00146327560383
Gc5_515 0 n10 ns515 0 -4.56522351336e-06
Gc5_516 0 n10 ns516 0 6.90870293296e-06
Gc5_517 0 n10 ns517 0 1.37362646955e-05
Gc5_518 0 n10 ns518 0 -2.18201798236e-05
Gc5_519 0 n10 ns519 0 4.61530749812e-08
Gc5_520 0 n10 ns520 0 -5.63226002464e-08
Gc5_521 0 n10 ns521 0 0.000536046820438
Gc5_522 0 n10 ns522 0 3.09942819221e-05
Gc5_523 0 n10 ns523 0 0.000368669184731
Gc5_524 0 n10 ns524 0 -0.000219505496634
Gc5_525 0 n10 ns525 0 1.33310944539e-05
Gc5_526 0 n10 ns526 0 3.12080881146e-06
Gc5_527 0 n10 ns527 0 -7.74900734573e-05
Gc5_528 0 n10 ns528 0 1.02112609249e-05
Gc5_529 0 n10 ns529 0 -3.56436367554e-05
Gc5_530 0 n10 ns530 0 0.000126340837261
Gc5_531 0 n10 ns531 0 0.000989857539531
Gc5_532 0 n10 ns532 0 0.00316973273951
Gc5_533 0 n10 ns533 0 3.97741918683e-05
Gc5_534 0 n10 ns534 0 -2.53258613651e-05
Gc5_535 0 n10 ns535 0 -0.0162760901093
Gc5_536 0 n10 ns536 0 -0.00186562804317
Gc5_537 0 n10 ns537 0 -0.00508942310624
Gc5_538 0 n10 ns538 0 0.00783225836677
Gc5_539 0 n10 ns539 0 -0.0128627114455
Gc5_540 0 n10 ns540 0 -2.36977540299e-05
Gc5_541 0 n10 ns541 0 3.32440302675e-05
Gc5_542 0 n10 ns542 0 1.93463355173e-05
Gc5_543 0 n10 ns543 0 4.60704996015e-07
Gc5_544 0 n10 ns544 0 -1.20934073653e-07
Gc5_545 0 n10 ns545 0 9.18299714266e-07
Gc5_546 0 n10 ns546 0 3.29634095703e-06
Gc5_547 0 n10 ns547 0 0.000477219988156
Gc5_548 0 n10 ns548 0 -0.000537429586118
Gc5_549 0 n10 ns549 0 9.36960420004e-08
Gc5_550 0 n10 ns550 0 -8.27207141785e-07
Gc5_551 0 n10 ns551 0 -0.00184581969675
Gc5_552 0 n10 ns552 0 -0.000344791733541
Gc5_553 0 n10 ns553 0 1.1855745901e-05
Gc5_554 0 n10 ns554 0 1.73231194791e-06
Gc5_555 0 n10 ns555 0 -0.000203270125924
Gc5_556 0 n10 ns556 0 4.42128848035e-06
Gc5_557 0 n10 ns557 0 0.00720615367119
Gc5_558 0 n10 ns558 0 0.00158775846373
Gc5_559 0 n10 ns559 0 0.00536648507028
Gc5_560 0 n10 ns560 0 -0.00584422844869
Gc5_561 0 n10 ns561 0 8.21557282022e-06
Gc5_562 0 n10 ns562 0 4.45087132868e-05
Gc5_563 0 n10 ns563 0 -1.36015055856e-05
Gc5_564 0 n10 ns564 0 -1.20255552338e-05
Gc5_565 0 n10 ns565 0 -5.27575962297e-06
Gc5_566 0 n10 ns566 0 -6.08020147412e-05
Gc5_567 0 n10 ns567 0 -0.000267747663235
Gc5_568 0 n10 ns568 0 -0.000144846563735
Gc5_569 0 n10 ns569 0 0.00150258258743
Gc5_570 0 n10 ns570 0 -0.00243732074656
Gc5_571 0 n10 ns571 0 -4.85608808136e-06
Gc5_572 0 n10 ns572 0 -7.09925577737e-05
Gc5_573 0 n10 ns573 0 1.11341424482e-05
Gc5_574 0 n10 ns574 0 -3.2260143553e-05
Gc5_575 0 n10 ns575 0 1.63382528719e-05
Gc5_576 0 n10 ns576 0 -1.88228842481e-05
Gc5_577 0 n10 ns577 0 5.20479429975e-06
Gc5_578 0 n10 ns578 0 -1.54137702309e-05
Gc5_579 0 n10 ns579 0 3.99387464047e-06
Gc5_580 0 n10 ns580 0 -1.89910077995e-05
Gc5_581 0 n10 ns581 0 -6.44929210905e-05
Gc5_582 0 n10 ns582 0 -2.10119888428e-05
Gc5_583 0 n10 ns583 0 -2.96265114233e-06
Gc5_584 0 n10 ns584 0 1.81899926494e-06
Gc5_585 0 n10 ns585 0 2.69702091998e-05
Gc5_586 0 n10 ns586 0 4.6312245315e-06
Gc5_587 0 n10 ns587 0 -4.43056544345e-07
Gc5_588 0 n10 ns588 0 -5.94713586358e-07
Gc5_589 0 n10 ns589 0 -2.93478970956e-06
Gc5_590 0 n10 ns590 0 1.85104751661e-05
Gc5_591 0 n10 ns591 0 -8.37548292989e-06
Gc5_592 0 n10 ns592 0 -1.14747303141e-09
Gc5_593 0 n10 ns593 0 -2.02248740246e-06
Gc5_594 0 n10 ns594 0 7.27737659003e-07
Gc5_595 0 n10 ns595 0 -4.13286813464e-06
Gc5_596 0 n10 ns596 0 -3.92322540062e-06
Gc5_597 0 n10 ns597 0 4.06654649474e-06
Gc5_598 0 n10 ns598 0 9.72996532597e-07
Gc5_599 0 n10 ns599 0 -4.78975361986e-07
Gc5_600 0 n10 ns600 0 5.77213508569e-07
Gc5_601 0 n10 ns601 0 -0.00540107722209
Gc5_602 0 n10 ns602 0 0.00217003132378
Gc5_603 0 n10 ns603 0 -0.000632517112015
Gc5_604 0 n10 ns604 0 0.000215040080692
Gc5_605 0 n10 ns605 0 -1.46508913142e-05
Gc5_606 0 n10 ns606 0 -4.29517190573e-05
Gc5_607 0 n10 ns607 0 2.78760676532e-05
Gc5_608 0 n10 ns608 0 2.30299561951e-05
Gc5_609 0 n10 ns609 0 -1.60645508949e-07
Gc5_610 0 n10 ns610 0 8.51190860687e-08
Gc5_611 0 n10 ns611 0 -4.63218267589e-05
Gc5_612 0 n10 ns612 0 -5.46539552949e-05
Gc5_613 0 n10 ns613 0 4.53619841863e-05
Gc5_614 0 n10 ns614 0 2.08747309075e-06
Gc5_615 0 n10 ns615 0 -9.05756319691e-05
Gc5_616 0 n10 ns616 0 -1.19984085276e-05
Gc5_617 0 n10 ns617 0 1.25990912032e-05
Gc5_618 0 n10 ns618 0 5.42503913089e-05
Gc5_619 0 n10 ns619 0 -5.02118356298e-06
Gc5_620 0 n10 ns620 0 2.86620554189e-05
Gc5_621 0 n10 ns621 0 6.50188009788e-05
Gc5_622 0 n10 ns622 0 -4.40009528326e-05
Gc5_623 0 n10 ns623 0 -7.88434849651e-05
Gc5_624 0 n10 ns624 0 -7.30610147311e-05
Gc5_625 0 n10 ns625 0 3.21041784085e-06
Gc5_626 0 n10 ns626 0 -2.81750838936e-07
Gc5_627 0 n10 ns627 0 2.37477843191e-05
Gc5_628 0 n10 ns628 0 1.83763609527e-05
Gc5_629 0 n10 ns629 0 4.41136270949e-05
Gc5_630 0 n10 ns630 0 -0.000211997082744
Gc5_631 0 n10 ns631 0 -2.10069846855e-06
Gc5_632 0 n10 ns632 0 -2.42810844414e-06
Gc5_633 0 n10 ns633 0 2.10125573427e-06
Gc5_634 0 n10 ns634 0 7.48176822402e-06
Gc5_635 0 n10 ns635 0 -0.000232594216539
Gc5_636 0 n10 ns636 0 -0.000209642124184
Gc5_637 0 n10 ns637 0 2.00999727881e-05
Gc5_638 0 n10 ns638 0 3.92940615533e-06
Gc5_639 0 n10 ns639 0 -7.96802905883e-05
Gc5_640 0 n10 ns640 0 -4.60001938732e-05
Gc5_641 0 n10 ns641 0 -0.000229608092882
Gc5_642 0 n10 ns642 0 0.000392094128222
Gc5_643 0 n10 ns643 0 3.93288657417e-05
Gc5_644 0 n10 ns644 0 -4.90424490592e-05
Gc5_645 0 n10 ns645 0 4.91028704196e-06
Gc5_646 0 n10 ns646 0 -1.00750648332e-06
Gc5_647 0 n10 ns647 0 0.000113123802608
Gc5_648 0 n10 ns648 0 -0.000115947845103
Gc5_649 0 n10 ns649 0 3.27699030886e-05
Gc5_650 0 n10 ns650 0 1.28850444286e-05
Gc5_651 0 n10 ns651 0 -9.44012247129e-05
Gc5_652 0 n10 ns652 0 2.61133373196e-05
Gc5_653 0 n10 ns653 0 -6.70485325055e-05
Gc5_654 0 n10 ns654 0 -9.45579358399e-05
Gc5_655 0 n10 ns655 0 0.00029387894215
Gc5_656 0 n10 ns656 0 0.000238185787813
Gc5_657 0 n10 ns657 0 -1.21792787881e-06
Gc5_658 0 n10 ns658 0 1.27485363504e-05
Gc5_659 0 n10 ns659 0 -1.20011294123e-05
Gc5_660 0 n10 ns660 0 1.08848356454e-06
Gc5_661 0 n10 ns661 0 6.1453808819e-05
Gc5_662 0 n10 ns662 0 3.7732114184e-05
Gc5_663 0 n10 ns663 0 0.000370681149179
Gc5_664 0 n10 ns664 0 -0.000933273020047
Gc5_665 0 n10 ns665 0 1.36676948577e-06
Gc5_666 0 n10 ns666 0 8.93543024422e-06
Gc5_667 0 n10 ns667 0 1.17032653647e-05
Gc5_668 0 n10 ns668 0 -1.2195587623e-07
Gc5_669 0 n10 ns669 0 -7.07363214997e-07
Gc5_670 0 n10 ns670 0 1.20822105737e-07
Gc5_671 0 n10 ns671 0 0.00027555641352
Gc5_672 0 n10 ns672 0 -0.00108721204173
Gc5_673 0 n10 ns673 0 -0.000566200843298
Gc5_674 0 n10 ns674 0 -0.00032743452486
Gc5_675 0 n10 ns675 0 1.95179722678e-05
Gc5_676 0 n10 ns676 0 -1.46556882308e-05
Gc5_677 0 n10 ns677 0 6.99099693587e-07
Gc5_678 0 n10 ns678 0 -5.21319120577e-05
Gc5_679 0 n10 ns679 0 -3.36040496893e-05
Gc5_680 0 n10 ns680 0 2.11507857256e-05
Gc5_681 0 n10 ns681 0 -0.00156818502573
Gc5_682 0 n10 ns682 0 -0.000207136028575
Gc5_683 0 n10 ns683 0 -2.4404677137e-05
Gc5_684 0 n10 ns684 0 2.07086375036e-05
Gc5_685 0 n10 ns685 0 -0.0194308038015
Gc5_686 0 n10 ns686 0 0.0105258939014
Gc5_687 0 n10 ns687 0 0.00751356376517
Gc5_688 0 n10 ns688 0 0.010092818486
Gc5_689 0 n10 ns689 0 -0.0134270311644
Gc5_690 0 n10 ns690 0 0.000100700499502
Gc5_691 0 n10 ns691 0 -9.29410091641e-06
Gc5_692 0 n10 ns692 0 -1.95445194769e-05
Gc5_693 0 n10 ns693 0 -1.2941617862e-07
Gc5_694 0 n10 ns694 0 4.99727087976e-08
Gc5_695 0 n10 ns695 0 -9.63325925407e-07
Gc5_696 0 n10 ns696 0 -6.37467899302e-06
Gc5_697 0 n10 ns697 0 0.000474429131604
Gc5_698 0 n10 ns698 0 -0.000288502813284
Gc5_699 0 n10 ns699 0 -2.4433323605e-07
Gc5_700 0 n10 ns700 0 1.13790190809e-06
Gc5_701 0 n10 ns701 0 0.00141035765956
Gc5_702 0 n10 ns702 0 0.00116649027543
Gc5_703 0 n10 ns703 0 5.09544792216e-06
Gc5_704 0 n10 ns704 0 -1.74451355504e-06
Gc5_705 0 n10 ns705 0 -0.000205130459019
Gc5_706 0 n10 ns706 0 1.59657537991e-05
Gc5_707 0 n10 ns707 0 -0.002413898948
Gc5_708 0 n10 ns708 0 -0.000658026841894
Gc5_709 0 n10 ns709 0 -0.00405244163188
Gc5_710 0 n10 ns710 0 0.0025341670947
Gc5_711 0 n10 ns711 0 -4.11470502353e-05
Gc5_712 0 n10 ns712 0 -3.146300915e-05
Gc5_713 0 n10 ns713 0 2.46667401205e-06
Gc5_714 0 n10 ns714 0 -6.47191465726e-06
Gc5_715 0 n10 ns715 0 5.89925952044e-06
Gc5_716 0 n10 ns716 0 -5.02144400857e-05
Gc5_717 0 n10 ns717 0 0.000130413807142
Gc5_718 0 n10 ns718 0 -7.65210646042e-05
Gc5_719 0 n10 ns719 0 -0.000782397382351
Gc5_720 0 n10 ns720 0 -0.00221619868712
Gc5_721 0 n10 ns721 0 -6.4710707916e-05
Gc5_722 0 n10 ns722 0 3.34912421298e-05
Gc5_723 0 n10 ns723 0 4.64661117801e-05
Gc5_724 0 n10 ns724 0 6.50940656705e-06
Gc5_725 0 n10 ns725 0 3.95238141278e-06
Gc5_726 0 n10 ns726 0 1.1129149559e-05
Gc5_727 0 n10 ns727 0 1.75532913989e-06
Gc5_728 0 n10 ns728 0 2.1626842452e-05
Gc5_729 0 n10 ns729 0 1.80308595598e-05
Gc5_730 0 n10 ns730 0 3.05015584052e-05
Gc5_731 0 n10 ns731 0 2.47660224001e-05
Gc5_732 0 n10 ns732 0 2.26392944891e-05
Gc5_733 0 n10 ns733 0 8.26554979095e-06
Gc5_734 0 n10 ns734 0 3.41269593775e-08
Gc5_735 0 n10 ns735 0 -3.03732867409e-05
Gc5_736 0 n10 ns736 0 1.16031780968e-05
Gc5_737 0 n10 ns737 0 7.09768880676e-07
Gc5_738 0 n10 ns738 0 -2.32230278557e-06
Gc5_739 0 n10 ns739 0 5.2571136646e-05
Gc5_740 0 n10 ns740 0 -9.42596047754e-06
Gc5_741 0 n10 ns741 0 3.80963933549e-07
Gc5_742 0 n10 ns742 0 -1.38818420453e-06
Gc5_743 0 n10 ns743 0 -6.65951413672e-07
Gc5_744 0 n10 ns744 0 -2.26434163525e-07
Gc5_745 0 n10 ns745 0 2.1493529764e-06
Gc5_746 0 n10 ns746 0 3.55730444056e-07
Gc5_747 0 n10 ns747 0 -2.46776534743e-06
Gc5_748 0 n10 ns748 0 -4.98792681689e-06
Gc5_749 0 n10 ns749 0 -2.06406603587e-06
Gc5_750 0 n10 ns750 0 -6.59634367708e-07
Gc5_751 0 n10 ns751 0 -0.000519493354901
Gc5_752 0 n10 ns752 0 0.00376582229968
Gc5_753 0 n10 ns753 0 -0.000290725202021
Gc5_754 0 n10 ns754 0 5.40085179911e-05
Gc5_755 0 n10 ns755 0 5.78097593712e-05
Gc5_756 0 n10 ns756 0 -0.000146576141249
Gc5_757 0 n10 ns757 0 -1.33782030657e-05
Gc5_758 0 n10 ns758 0 -2.48834362633e-05
Gc5_759 0 n10 ns759 0 9.56535938864e-08
Gc5_760 0 n10 ns760 0 8.97166033757e-08
Gc5_761 0 n10 ns761 0 -9.15704798959e-05
Gc5_762 0 n10 ns762 0 7.49244734747e-05
Gc5_763 0 n10 ns763 0 -0.000102595966109
Gc5_764 0 n10 ns764 0 -5.1135911876e-05
Gc5_765 0 n10 ns765 0 -6.6495059056e-05
Gc5_766 0 n10 ns766 0 -1.34789454912e-05
Gc5_767 0 n10 ns767 0 -0.000127797701988
Gc5_768 0 n10 ns768 0 -5.24643893969e-05
Gc5_769 0 n10 ns769 0 1.38644759937e-07
Gc5_770 0 n10 ns770 0 4.93539403934e-06
Gc5_771 0 n10 ns771 0 5.10832264307e-05
Gc5_772 0 n10 ns772 0 1.87397097317e-05
Gc5_773 0 n10 ns773 0 -0.000380078824139
Gc5_774 0 n10 ns774 0 0.000444089776358
Gc5_775 0 n10 ns775 0 9.562036774e-06
Gc5_776 0 n10 ns776 0 5.56793708329e-06
Gc5_777 0 n10 ns777 0 -2.72009560831e-05
Gc5_778 0 n10 ns778 0 -8.96262180623e-05
Gc5_779 0 n10 ns779 0 -0.000121340846667
Gc5_780 0 n10 ns780 0 -0.000208679284248
Gc5_781 0 n10 ns781 0 4.48893107298e-07
Gc5_782 0 n10 ns782 0 -3.41302904507e-06
Gc5_783 0 n10 ns783 0 -3.95491295531e-06
Gc5_784 0 n10 ns784 0 -5.77565858902e-07
Gc5_785 0 n10 ns785 0 6.86523668703e-05
Gc5_786 0 n10 ns786 0 0.000435040634414
Gc5_787 0 n10 ns787 0 -5.94982247655e-06
Gc5_788 0 n10 ns788 0 -2.76221549654e-05
Gc5_789 0 n10 ns789 0 3.3909637778e-06
Gc5_790 0 n10 ns790 0 1.6208229942e-05
Gc5_791 0 n10 ns791 0 -0.000954849597787
Gc5_792 0 n10 ns792 0 0.000127436595005
Gc5_793 0 n10 ns793 0 5.97714584984e-05
Gc5_794 0 n10 ns794 0 3.22325070387e-05
Gc5_795 0 n10 ns795 0 -1.38577488148e-06
Gc5_796 0 n10 ns796 0 -2.01913852382e-06
Gc5_797 0 n10 ns797 0 0.000129724607253
Gc5_798 0 n10 ns798 0 9.67372956557e-07
Gc5_799 0 n10 ns799 0 2.25438804479e-05
Gc5_800 0 n10 ns800 0 1.9186475241e-05
Gc5_801 0 n10 ns801 0 9.18927774943e-07
Gc5_802 0 n10 ns802 0 0.000165546185426
Gc5_803 0 n10 ns803 0 1.33507551986e-05
Gc5_804 0 n10 ns804 0 0.000187556182431
Gc5_805 0 n10 ns805 0 -0.000530893952837
Gc5_806 0 n10 ns806 0 0.000587615674334
Gc5_807 0 n10 ns807 0 -1.38559257989e-05
Gc5_808 0 n10 ns808 0 -2.5358474677e-05
Gc5_809 0 n10 ns809 0 9.79798408805e-06
Gc5_810 0 n10 ns810 0 -3.11780839669e-05
Gc5_811 0 n10 ns811 0 -0.000154802378385
Gc5_812 0 n10 ns812 0 4.84428471291e-05
Gc5_813 0 n10 ns813 0 -0.000378651759659
Gc5_814 0 n10 ns814 0 -0.000174070284313
Gc5_815 0 n10 ns815 0 -4.12001191771e-06
Gc5_816 0 n10 ns816 0 -4.91416683565e-06
Gc5_817 0 n10 ns817 0 3.86556908389e-05
Gc5_818 0 n10 ns818 0 -5.84676619888e-05
Gc5_819 0 n10 ns819 0 1.06366090428e-06
Gc5_820 0 n10 ns820 0 2.74788471065e-07
Gc5_821 0 n10 ns821 0 -0.000831263071464
Gc5_822 0 n10 ns822 0 0.000347630562705
Gc5_823 0 n10 ns823 0 4.616452369e-05
Gc5_824 0 n10 ns824 0 0.00082851531568
Gc5_825 0 n10 ns825 0 -4.1224183433e-06
Gc5_826 0 n10 ns826 0 -8.88247253857e-06
Gc5_827 0 n10 ns827 0 -0.000156080650864
Gc5_828 0 n10 ns828 0 -9.41360466431e-05
Gc5_829 0 n10 ns829 0 -0.000195664213906
Gc5_830 0 n10 ns830 0 0.00018729355275
Gc5_831 0 n10 ns831 0 -0.00203075888875
Gc5_832 0 n10 ns832 0 0.00196302823894
Gc5_833 0 n10 ns833 0 3.48453477213e-05
Gc5_834 0 n10 ns834 0 -2.03829896887e-05
Gc5_835 0 n10 ns835 0 0.0410210963436
Gc5_836 0 n10 ns836 0 0.0164993106032
Gc5_837 0 n10 ns837 0 -0.0104999567653
Gc5_838 0 n10 ns838 0 0.0112372931046
Gc5_839 0 n10 ns839 0 0.00731613005829
Gc5_840 0 n10 ns840 0 -0.000132066004809
Gc5_841 0 n10 ns841 0 2.68737116711e-05
Gc5_842 0 n10 ns842 0 1.41651939684e-05
Gc5_843 0 n10 ns843 0 2.367950515e-07
Gc5_844 0 n10 ns844 0 2.53477105652e-07
Gc5_845 0 n10 ns845 0 5.74240041127e-06
Gc5_846 0 n10 ns846 0 1.11150822279e-06
Gc5_847 0 n10 ns847 0 0.000605691995996
Gc5_848 0 n10 ns848 0 0.000281778452717
Gc5_849 0 n10 ns849 0 -1.21156148811e-06
Gc5_850 0 n10 ns850 0 -2.94065125191e-07
Gc5_851 0 n10 ns851 0 -0.00360823651559
Gc5_852 0 n10 ns852 0 -0.0010285997745
Gc5_853 0 n10 ns853 0 5.23160718484e-05
Gc5_854 0 n10 ns854 0 -4.92365077767e-06
Gc5_855 0 n10 ns855 0 -0.000152719535006
Gc5_856 0 n10 ns856 0 8.06275400073e-05
Gc5_857 0 n10 ns857 0 -0.00114496026538
Gc5_858 0 n10 ns858 0 0.0100183682402
Gc5_859 0 n10 ns859 0 0.00880224735397
Gc5_860 0 n10 ns860 0 0.0156722736019
Gc5_861 0 n10 ns861 0 -3.42832912298e-05
Gc5_862 0 n10 ns862 0 5.9102034744e-05
Gc5_863 0 n10 ns863 0 3.1296364849e-06
Gc5_864 0 n10 ns864 0 -1.07032778202e-05
Gc5_865 0 n10 ns865 0 -2.06995586316e-05
Gc5_866 0 n10 ns866 0 -9.65974075109e-05
Gc5_867 0 n10 ns867 0 -0.000129546746016
Gc5_868 0 n10 ns868 0 -0.000290559140368
Gc5_869 0 n10 ns869 0 0.00241588034946
Gc5_870 0 n10 ns870 0 0.00176799648969
Gc5_871 0 n10 ns871 0 -2.53493754805e-06
Gc5_872 0 n10 ns872 0 -6.73221931474e-06
Gc5_873 0 n10 ns873 0 1.02992530015e-05
Gc5_874 0 n10 ns874 0 -1.80186962301e-05
Gc5_875 0 n10 ns875 0 2.2751389914e-05
Gc5_876 0 n10 ns876 0 -1.03400631769e-05
Gc5_877 0 n10 ns877 0 -4.70134786598e-07
Gc5_878 0 n10 ns878 0 -1.08079624262e-05
Gc5_879 0 n10 ns879 0 -6.57217963131e-06
Gc5_880 0 n10 ns880 0 -2.2100688614e-05
Gc5_881 0 n10 ns881 0 -6.09448262416e-05
Gc5_882 0 n10 ns882 0 -2.16963231882e-05
Gc5_883 0 n10 ns883 0 1.08687289159e-06
Gc5_884 0 n10 ns884 0 5.17762044518e-06
Gc5_885 0 n10 ns885 0 2.39166295765e-05
Gc5_886 0 n10 ns886 0 -1.59424673897e-06
Gc5_887 0 n10 ns887 0 2.92968963079e-07
Gc5_888 0 n10 ns888 0 -2.87705650462e-08
Gc5_889 0 n10 ns889 0 -7.83536936384e-07
Gc5_890 0 n10 ns890 0 -1.60537526382e-05
Gc5_891 0 n10 ns891 0 -5.10378364007e-07
Gc5_892 0 n10 ns892 0 -8.68501558383e-06
Gc5_893 0 n10 ns893 0 -1.25157478909e-06
Gc5_894 0 n10 ns894 0 -2.07891799766e-06
Gc5_895 0 n10 ns895 0 2.34189954096e-06
Gc5_896 0 n10 ns896 0 -6.21394530191e-06
Gc5_897 0 n10 ns897 0 -4.8099944689e-06
Gc5_898 0 n10 ns898 0 1.16063978037e-06
Gc5_899 0 n10 ns899 0 -2.79861222074e-06
Gc5_900 0 n10 ns900 0 1.48304010612e-06
Gd5_1 0 n10 ni1 0 0.000926040474809
Gd5_2 0 n10 ni2 0 -0.00031451540756
Gd5_3 0 n10 ni3 0 0.0011517913878
Gd5_4 0 n10 ni4 0 0.000250549357052
Gd5_5 0 n10 ni5 0 -0.00818132954428
Gd5_6 0 n10 ni6 0 0.000224939503148
Gc6_1 0 n12 ns1 0 0.00319458910459
Gc6_2 0 n12 ns2 0 -0.00149710121956
Gc6_3 0 n12 ns3 0 -0.00138634407584
Gc6_4 0 n12 ns4 0 -0.000326413728636
Gc6_5 0 n12 ns5 0 0.000275253393561
Gc6_6 0 n12 ns6 0 4.10290904635e-05
Gc6_7 0 n12 ns7 0 -0.000221178779415
Gc6_8 0 n12 ns8 0 0.00018513071539
Gc6_9 0 n12 ns9 0 -3.32686947726e-08
Gc6_10 0 n12 ns10 0 -9.53699029909e-08
Gc6_11 0 n12 ns11 0 -0.000180576154201
Gc6_12 0 n12 ns12 0 -5.99263372554e-05
Gc6_13 0 n12 ns13 0 -5.83928261684e-05
Gc6_14 0 n12 ns14 0 -0.000106841229032
Gc6_15 0 n12 ns15 0 -3.7128704813e-05
Gc6_16 0 n12 ns16 0 -0.000176104330856
Gc6_17 0 n12 ns17 0 0.000126030184103
Gc6_18 0 n12 ns18 0 0.000174085941619
Gc6_19 0 n12 ns19 0 -0.000278014998143
Gc6_20 0 n12 ns20 0 0.00032024390968
Gc6_21 0 n12 ns21 0 8.74861127638e-05
Gc6_22 0 n12 ns22 0 0.000163941456532
Gc6_23 0 n12 ns23 0 -0.000668610400906
Gc6_24 0 n12 ns24 0 -0.000285113845053
Gc6_25 0 n12 ns25 0 1.76736525966e-05
Gc6_26 0 n12 ns26 0 1.08348493937e-05
Gc6_27 0 n12 ns27 0 1.13214495773e-05
Gc6_28 0 n12 ns28 0 -0.00016346783019
Gc6_29 0 n12 ns29 0 0.000189447069636
Gc6_30 0 n12 ns30 0 0.00103552863586
Gc6_31 0 n12 ns31 0 -1.00028763818e-06
Gc6_32 0 n12 ns32 0 -5.53511526984e-07
Gc6_33 0 n12 ns33 0 5.97231921585e-06
Gc6_34 0 n12 ns34 0 1.20954349239e-05
Gc6_35 0 n12 ns35 0 -0.000633576159047
Gc6_36 0 n12 ns36 0 0.000448435698451
Gc6_37 0 n12 ns37 0 3.36646837327e-05
Gc6_38 0 n12 ns38 0 -2.61747731202e-05
Gc6_39 0 n12 ns39 0 9.53025416191e-06
Gc6_40 0 n12 ns40 0 7.155466015e-07
Gc6_41 0 n12 ns41 0 0.000613814985373
Gc6_42 0 n12 ns42 0 -3.22611207365e-05
Gc6_43 0 n12 ns43 0 -5.43676176136e-05
Gc6_44 0 n12 ns44 0 9.89271851199e-05
Gc6_45 0 n12 ns45 0 -1.52476452049e-06
Gc6_46 0 n12 ns46 0 -8.41155542881e-06
Gc6_47 0 n12 ns47 0 0.000125881001389
Gc6_48 0 n12 ns48 0 0.00032945938697
Gc6_49 0 n12 ns49 0 0.000130476565201
Gc6_50 0 n12 ns50 0 9.60665643297e-05
Gc6_51 0 n12 ns51 0 -0.000205555072046
Gc6_52 0 n12 ns52 0 0.000291216229347
Gc6_53 0 n12 ns53 0 -0.000142567800435
Gc6_54 0 n12 ns54 0 7.26627542871e-05
Gc6_55 0 n12 ns55 0 0.000147381037279
Gc6_56 0 n12 ns56 0 -0.000473800407227
Gc6_57 0 n12 ns57 0 -1.92076104861e-05
Gc6_58 0 n12 ns58 0 4.41505750632e-05
Gc6_59 0 n12 ns59 0 1.69768157292e-05
Gc6_60 0 n12 ns60 0 -2.53675603042e-05
Gc6_61 0 n12 ns61 0 -0.000133060548757
Gc6_62 0 n12 ns62 0 6.02104114961e-05
Gc6_63 0 n12 ns63 0 0.00124258689546
Gc6_64 0 n12 ns64 0 0.00116909888845
Gc6_65 0 n12 ns65 0 1.09417119776e-05
Gc6_66 0 n12 ns66 0 6.48098701713e-06
Gc6_67 0 n12 ns67 0 4.84497841629e-05
Gc6_68 0 n12 ns68 0 -5.4858893318e-05
Gc6_69 0 n12 ns69 0 1.31279443932e-06
Gc6_70 0 n12 ns70 0 5.5857051571e-08
Gc6_71 0 n12 ns71 0 -0.000407897644777
Gc6_72 0 n12 ns72 0 -0.000542590671268
Gc6_73 0 n12 ns73 0 -0.000255996996576
Gc6_74 0 n12 ns74 0 -7.79161921369e-05
Gc6_75 0 n12 ns75 0 8.88380267715e-06
Gc6_76 0 n12 ns76 0 -1.11907128053e-05
Gc6_77 0 n12 ns77 0 -7.01648428401e-05
Gc6_78 0 n12 ns78 0 9.05755791447e-06
Gc6_79 0 n12 ns79 0 -1.57086248217e-05
Gc6_80 0 n12 ns80 0 0.000113401535758
Gc6_81 0 n12 ns81 0 0.00209755415267
Gc6_82 0 n12 ns82 0 0.000847966312285
Gc6_83 0 n12 ns83 0 2.00866812119e-05
Gc6_84 0 n12 ns84 0 -5.80763823043e-05
Gc6_85 0 n12 ns85 0 -0.0133135725779
Gc6_86 0 n12 ns86 0 0.00324622948164
Gc6_87 0 n12 ns87 0 -0.00313093503678
Gc6_88 0 n12 ns88 0 0.00162629115597
Gc6_89 0 n12 ns89 0 -0.0102344657612
Gc6_90 0 n12 ns90 0 3.87221296871e-06
Gc6_91 0 n12 ns91 0 4.17783744224e-05
Gc6_92 0 n12 ns92 0 -1.22889439557e-05
Gc6_93 0 n12 ns93 0 -2.53203887127e-08
Gc6_94 0 n12 ns94 0 -1.38529301235e-07
Gc6_95 0 n12 ns95 0 6.52518343658e-06
Gc6_96 0 n12 ns96 0 6.038663792e-06
Gc6_97 0 n12 ns97 0 -0.000161166254039
Gc6_98 0 n12 ns98 0 -0.000410662161161
Gc6_99 0 n12 ns99 0 -8.90507826324e-07
Gc6_100 0 n12 ns100 0 -1.11669413175e-06
Gc6_101 0 n12 ns101 0 -0.00152153654392
Gc6_102 0 n12 ns102 0 0.000173849020209
Gc6_103 0 n12 ns103 0 1.37115731125e-05
Gc6_104 0 n12 ns104 0 -7.40034089157e-06
Gc6_105 0 n12 ns105 0 -0.00017511660934
Gc6_106 0 n12 ns106 0 0.000151248576581
Gc6_107 0 n12 ns107 0 0.00288603419088
Gc6_108 0 n12 ns108 0 -0.00229490933061
Gc6_109 0 n12 ns109 0 -0.000749598234765
Gc6_110 0 n12 ns110 0 -0.0043848361977
Gc6_111 0 n12 ns111 0 -2.53537209849e-06
Gc6_112 0 n12 ns112 0 3.06235963052e-05
Gc6_113 0 n12 ns113 0 -1.19463976675e-05
Gc6_114 0 n12 ns114 0 -5.91798044589e-06
Gc6_115 0 n12 ns115 0 -3.45161462583e-05
Gc6_116 0 n12 ns116 0 -5.51669010067e-05
Gc6_117 0 n12 ns117 0 -0.000207438328118
Gc6_118 0 n12 ns118 0 -6.83456109685e-05
Gc6_119 0 n12 ns119 0 -0.00067221067055
Gc6_120 0 n12 ns120 0 -0.00176869989938
Gc6_121 0 n12 ns121 0 -4.41067777748e-05
Gc6_122 0 n12 ns122 0 -3.44673311302e-05
Gc6_123 0 n12 ns123 0 -1.29865673459e-05
Gc6_124 0 n12 ns124 0 -4.25232063851e-05
Gc6_125 0 n12 ns125 0 1.9023100204e-06
Gc6_126 0 n12 ns126 0 -2.32158851722e-05
Gc6_127 0 n12 ns127 0 -4.11258239157e-06
Gc6_128 0 n12 ns128 0 -1.77938170219e-05
Gc6_129 0 n12 ns129 0 -4.82558814591e-06
Gc6_130 0 n12 ns130 0 -3.03946343583e-05
Gc6_131 0 n12 ns131 0 -5.53138685387e-05
Gc6_132 0 n12 ns132 0 1.88457527412e-05
Gc6_133 0 n12 ns133 0 2.58852353848e-06
Gc6_134 0 n12 ns134 0 7.99798710098e-06
Gc6_135 0 n12 ns135 0 2.44663480144e-05
Gc6_136 0 n12 ns136 0 -1.36299332134e-05
Gc6_137 0 n12 ns137 0 -1.28893854808e-06
Gc6_138 0 n12 ns138 0 2.31738844978e-07
Gc6_139 0 n12 ns139 0 3.5246908158e-05
Gc6_140 0 n12 ns140 0 7.67759096862e-06
Gc6_141 0 n12 ns141 0 1.49008138601e-06
Gc6_142 0 n12 ns142 0 -2.02468762168e-06
Gc6_143 0 n12 ns143 0 -5.32387543041e-07
Gc6_144 0 n12 ns144 0 -1.0561921001e-06
Gc6_145 0 n12 ns145 0 1.79894149044e-06
Gc6_146 0 n12 ns146 0 -6.11226115427e-08
Gc6_147 0 n12 ns147 0 -4.53283554544e-07
Gc6_148 0 n12 ns148 0 -8.78864781701e-06
Gc6_149 0 n12 ns149 0 -1.50820789307e-06
Gc6_150 0 n12 ns150 0 -1.32168244547e-06
Gc6_151 0 n12 ns151 0 -0.000203656646478
Gc6_152 0 n12 ns152 0 0.000604232433607
Gc6_153 0 n12 ns153 0 -0.000136379224191
Gc6_154 0 n12 ns154 0 -0.000319484219292
Gc6_155 0 n12 ns155 0 5.2243686624e-05
Gc6_156 0 n12 ns156 0 -5.70555730393e-05
Gc6_157 0 n12 ns157 0 2.65720849341e-07
Gc6_158 0 n12 ns158 0 -6.6586219576e-05
Gc6_159 0 n12 ns159 0 4.14294610236e-08
Gc6_160 0 n12 ns160 0 -8.67494595284e-10
Gc6_161 0 n12 ns161 0 5.51359046916e-05
Gc6_162 0 n12 ns162 0 8.33733114384e-05
Gc6_163 0 n12 ns163 0 -4.56392475653e-06
Gc6_164 0 n12 ns164 0 -3.37159268206e-05
Gc6_165 0 n12 ns165 0 2.15277516833e-05
Gc6_166 0 n12 ns166 0 -1.62732584937e-06
Gc6_167 0 n12 ns167 0 5.90328611385e-05
Gc6_168 0 n12 ns168 0 -8.38200731719e-05
Gc6_169 0 n12 ns169 0 -8.46716583671e-05
Gc6_170 0 n12 ns170 0 -0.000176188199649
Gc6_171 0 n12 ns171 0 -3.86873356631e-05
Gc6_172 0 n12 ns172 0 -5.34366864878e-05
Gc6_173 0 n12 ns173 0 -0.000235849139112
Gc6_174 0 n12 ns174 0 0.000433184556902
Gc6_175 0 n12 ns175 0 1.93687490997e-05
Gc6_176 0 n12 ns176 0 -8.63554113117e-06
Gc6_177 0 n12 ns177 0 1.68917725553e-05
Gc6_178 0 n12 ns178 0 -9.76875219543e-06
Gc6_179 0 n12 ns179 0 2.11866753878e-05
Gc6_180 0 n12 ns180 0 0.000471316043473
Gc6_181 0 n12 ns181 0 -2.4163889249e-06
Gc6_182 0 n12 ns182 0 -5.58131624678e-06
Gc6_183 0 n12 ns183 0 1.13380675521e-05
Gc6_184 0 n12 ns184 0 1.31970982108e-06
Gc6_185 0 n12 ns185 0 0.000467153824907
Gc6_186 0 n12 ns186 0 -0.000103998237873
Gc6_187 0 n12 ns187 0 -2.89295370908e-05
Gc6_188 0 n12 ns188 0 4.25826018008e-06
Gc6_189 0 n12 ns189 0 -3.86486855946e-05
Gc6_190 0 n12 ns190 0 0.000118254817241
Gc6_191 0 n12 ns191 0 0.000795876994349
Gc6_192 0 n12 ns192 0 -0.000250020866219
Gc6_193 0 n12 ns193 0 -0.000155036251687
Gc6_194 0 n12 ns194 0 -6.84949639021e-06
Gc6_195 0 n12 ns195 0 6.2001062982e-06
Gc6_196 0 n12 ns196 0 -2.99265435955e-06
Gc6_197 0 n12 ns197 0 2.21274685805e-05
Gc6_198 0 n12 ns198 0 0.000116301775065
Gc6_199 0 n12 ns199 0 4.06627368265e-05
Gc6_200 0 n12 ns200 0 -6.24276306123e-06
Gc6_201 0 n12 ns201 0 8.34515806691e-05
Gc6_202 0 n12 ns202 0 4.83057151653e-05
Gc6_203 0 n12 ns203 0 8.18946891907e-05
Gc6_204 0 n12 ns204 0 -0.000103819120445
Gc6_205 0 n12 ns205 0 0.000260483222727
Gc6_206 0 n12 ns206 0 0.000263999675347
Gc6_207 0 n12 ns207 0 7.01079205294e-06
Gc6_208 0 n12 ns208 0 7.63385767949e-06
Gc6_209 0 n12 ns209 0 -2.25802768398e-05
Gc6_210 0 n12 ns210 0 4.84686239314e-05
Gc6_211 0 n12 ns211 0 0.000200750119212
Gc6_212 0 n12 ns212 0 -8.14754212264e-05
Gc6_213 0 n12 ns213 0 0.000406308998345
Gc6_214 0 n12 ns214 0 -0.000261781222137
Gc6_215 0 n12 ns215 0 -1.91209772021e-06
Gc6_216 0 n12 ns216 0 9.08741956845e-06
Gc6_217 0 n12 ns217 0 3.05585621083e-05
Gc6_218 0 n12 ns218 0 1.91381238679e-05
Gc6_219 0 n12 ns219 0 9.6624704416e-08
Gc6_220 0 n12 ns220 0 6.61279156807e-07
Gc6_221 0 n12 ns221 0 0.000347780985246
Gc6_222 0 n12 ns222 0 -8.1592997219e-05
Gc6_223 0 n12 ns223 0 0.000203334201752
Gc6_224 0 n12 ns224 0 -0.000162620422336
Gc6_225 0 n12 ns225 0 8.83546295525e-06
Gc6_226 0 n12 ns226 0 -5.01953607622e-06
Gc6_227 0 n12 ns227 0 -2.75481725184e-05
Gc6_228 0 n12 ns228 0 9.84943561349e-05
Gc6_229 0 n12 ns229 0 0.000197282626453
Gc6_230 0 n12 ns230 0 2.20468063178e-05
Gc6_231 0 n12 ns231 0 -0.000103761673356
Gc6_232 0 n12 ns232 0 -0.00205347595578
Gc6_233 0 n12 ns233 0 -4.20930433515e-05
Gc6_234 0 n12 ns234 0 5.48527881958e-06
Gc6_235 0 n12 ns235 0 -0.00205232628825
Gc6_236 0 n12 ns236 0 0.00642368476922
Gc6_237 0 n12 ns237 0 0.00242248053247
Gc6_238 0 n12 ns238 0 -0.000231879449808
Gc6_239 0 n12 ns239 0 -0.00655546536745
Gc6_240 0 n12 ns240 0 2.20965772113e-08
Gc6_241 0 n12 ns241 0 -2.38375836057e-05
Gc6_242 0 n12 ns242 0 1.2559691465e-05
Gc6_243 0 n12 ns243 0 -2.75505183228e-07
Gc6_244 0 n12 ns244 0 -4.89446231252e-08
Gc6_245 0 n12 ns245 0 -5.79170121308e-06
Gc6_246 0 n12 ns246 0 -1.10223619006e-05
Gc6_247 0 n12 ns247 0 -0.000258253419442
Gc6_248 0 n12 ns248 0 -0.00104102974891
Gc6_249 0 n12 ns249 0 2.03022556351e-08
Gc6_250 0 n12 ns250 0 -4.41820103002e-07
Gc6_251 0 n12 ns251 0 0.00206556628118
Gc6_252 0 n12 ns252 0 -0.000941719512232
Gc6_253 0 n12 ns253 0 -9.36716863462e-06
Gc6_254 0 n12 ns254 0 2.81489525282e-05
Gc6_255 0 n12 ns255 0 -0.000288397556908
Gc6_256 0 n12 ns256 0 0.000104952776609
Gc6_257 0 n12 ns257 0 -0.0023299988045
Gc6_258 0 n12 ns258 0 -0.000512454884753
Gc6_259 0 n12 ns259 0 0.000158275624656
Gc6_260 0 n12 ns260 0 0.00445117537424
Gc6_261 0 n12 ns261 0 8.16725892602e-05
Gc6_262 0 n12 ns262 0 1.44847264931e-05
Gc6_263 0 n12 ns263 0 -1.51327386564e-05
Gc6_264 0 n12 ns264 0 1.16247560063e-06
Gc6_265 0 n12 ns265 0 -1.15673805336e-05
Gc6_266 0 n12 ns266 0 -3.09085325735e-05
Gc6_267 0 n12 ns267 0 0.000154034763301
Gc6_268 0 n12 ns268 0 0.000313674498624
Gc6_269 0 n12 ns269 0 -0.00186828825764
Gc6_270 0 n12 ns270 0 -0.000743197649191
Gc6_271 0 n12 ns271 0 4.47897400246e-05
Gc6_272 0 n12 ns272 0 -5.86797227402e-05
Gc6_273 0 n12 ns273 0 -2.38504523904e-05
Gc6_274 0 n12 ns274 0 -4.92103954045e-06
Gc6_275 0 n12 ns275 0 -2.59470412754e-05
Gc6_276 0 n12 ns276 0 1.47643586629e-06
Gc6_277 0 n12 ns277 0 -4.054941017e-06
Gc6_278 0 n12 ns278 0 1.66064271087e-05
Gc6_279 0 n12 ns279 0 -7.09680519169e-06
Gc6_280 0 n12 ns280 0 -1.87130514759e-05
Gc6_281 0 n12 ns281 0 6.42515597037e-05
Gc6_282 0 n12 ns282 0 2.3196485176e-05
Gc6_283 0 n12 ns283 0 1.73456789631e-05
Gc6_284 0 n12 ns284 0 -1.34089682167e-05
Gc6_285 0 n12 ns285 0 -2.78034895631e-05
Gc6_286 0 n12 ns286 0 3.59862832963e-06
Gc6_287 0 n12 ns287 0 -2.63653747538e-07
Gc6_288 0 n12 ns288 0 -1.72213276981e-07
Gc6_289 0 n12 ns289 0 -2.84068239718e-05
Gc6_290 0 n12 ns290 0 -3.11189510012e-05
Gc6_291 0 n12 ns291 0 -3.47583578106e-06
Gc6_292 0 n12 ns292 0 7.91618722537e-08
Gc6_293 0 n12 ns293 0 -6.39593269777e-07
Gc6_294 0 n12 ns294 0 2.03530066986e-07
Gc6_295 0 n12 ns295 0 9.56713482467e-07
Gc6_296 0 n12 ns296 0 -2.24985832617e-06
Gc6_297 0 n12 ns297 0 2.43529547659e-06
Gc6_298 0 n12 ns298 0 4.84936884304e-06
Gc6_299 0 n12 ns299 0 2.398225004e-06
Gc6_300 0 n12 ns300 0 1.83837467753e-06
Gc6_301 0 n12 ns301 0 0.000129123378887
Gc6_302 0 n12 ns302 0 0.00245953558164
Gc6_303 0 n12 ns303 0 -0.000562807943496
Gc6_304 0 n12 ns304 0 0.000153218002746
Gc6_305 0 n12 ns305 0 -0.000270837781165
Gc6_306 0 n12 ns306 0 3.40120529375e-06
Gc6_307 0 n12 ns307 0 -2.94002466836e-05
Gc6_308 0 n12 ns308 0 -1.60663069526e-05
Gc6_309 0 n12 ns309 0 1.04715572664e-08
Gc6_310 0 n12 ns310 0 1.12506533372e-07
Gc6_311 0 n12 ns311 0 3.9607433929e-05
Gc6_312 0 n12 ns312 0 0.0001221155375
Gc6_313 0 n12 ns313 0 -7.85042637324e-05
Gc6_314 0 n12 ns314 0 8.60872989808e-05
Gc6_315 0 n12 ns315 0 9.59015977598e-05
Gc6_316 0 n12 ns316 0 0.000156877696992
Gc6_317 0 n12 ns317 0 -0.000158960170273
Gc6_318 0 n12 ns318 0 0.000143404106651
Gc6_319 0 n12 ns319 0 -0.000177779510305
Gc6_320 0 n12 ns320 0 -0.00010670284702
Gc6_321 0 n12 ns321 0 1.44457395995e-05
Gc6_322 0 n12 ns322 0 -7.84980453276e-07
Gc6_323 0 n12 ns323 0 0.000183919453041
Gc6_324 0 n12 ns324 0 0.000370974349207
Gc6_325 0 n12 ns325 0 1.32266973334e-05
Gc6_326 0 n12 ns326 0 -7.37443975536e-06
Gc6_327 0 n12 ns327 0 0.000125953754617
Gc6_328 0 n12 ns328 0 9.91685153566e-07
Gc6_329 0 n12 ns329 0 -0.000790995012292
Gc6_330 0 n12 ns330 0 0.000360185391506
Gc6_331 0 n12 ns331 0 -2.95160264682e-06
Gc6_332 0 n12 ns332 0 6.84683283547e-07
Gc6_333 0 n12 ns333 0 -2.51474738925e-06
Gc6_334 0 n12 ns334 0 8.51960606197e-06
Gc6_335 0 n12 ns335 0 -6.94943536373e-05
Gc6_336 0 n12 ns336 0 4.18363802144e-05
Gc6_337 0 n12 ns337 0 -1.02240150651e-06
Gc6_338 0 n12 ns338 0 -2.14522570122e-05
Gc6_339 0 n12 ns339 0 5.34791194283e-05
Gc6_340 0 n12 ns340 0 9.74583957974e-05
Gc6_341 0 n12 ns341 0 0.000297234176709
Gc6_342 0 n12 ns342 0 0.00124785439925
Gc6_343 0 n12 ns343 0 -0.000115223734677
Gc6_344 0 n12 ns344 0 -3.56475258533e-05
Gc6_345 0 n12 ns345 0 6.78662696376e-06
Gc6_346 0 n12 ns346 0 -1.6498634366e-05
Gc6_347 0 n12 ns347 0 -6.26486253227e-05
Gc6_348 0 n12 ns348 0 0.000196875922946
Gc6_349 0 n12 ns349 0 3.74700629075e-05
Gc6_350 0 n12 ns350 0 9.76191194808e-05
Gc6_351 0 n12 ns351 0 -0.00010117864292
Gc6_352 0 n12 ns352 0 0.000105579683212
Gc6_353 0 n12 ns353 0 4.89865535879e-05
Gc6_354 0 n12 ns354 0 -3.31099133793e-06
Gc6_355 0 n12 ns355 0 0.000781917474402
Gc6_356 0 n12 ns356 0 0.000329239388233
Gc6_357 0 n12 ns357 0 -5.5156223889e-05
Gc6_358 0 n12 ns358 0 3.79615317858e-05
Gc6_359 0 n12 ns359 0 -8.38367130436e-06
Gc6_360 0 n12 ns360 0 -5.16063298371e-05
Gc6_361 0 n12 ns361 0 -0.000216518138852
Gc6_362 0 n12 ns362 0 0.00020091510541
Gc6_363 0 n12 ns363 0 0.000323993695563
Gc6_364 0 n12 ns364 0 0.00160969274891
Gc6_365 0 n12 ns365 0 1.12883348741e-06
Gc6_366 0 n12 ns366 0 1.16553696551e-05
Gc6_367 0 n12 ns367 0 2.67255109658e-05
Gc6_368 0 n12 ns368 0 -5.40359569335e-05
Gc6_369 0 n12 ns369 0 1.12412574184e-06
Gc6_370 0 n12 ns370 0 -5.5984104037e-07
Gc6_371 0 n12 ns371 0 0.000333676590217
Gc6_372 0 n12 ns372 0 -6.82880437169e-05
Gc6_373 0 n12 ns373 0 0.00027576155957
Gc6_374 0 n12 ns374 0 -0.000204172496462
Gc6_375 0 n12 ns375 0 1.39318290361e-05
Gc6_376 0 n12 ns376 0 -5.21817507385e-06
Gc6_377 0 n12 ns377 0 -9.71260164434e-05
Gc6_378 0 n12 ns378 0 1.06323457917e-05
Gc6_379 0 n12 ns379 0 -4.1541558387e-05
Gc6_380 0 n12 ns380 0 0.000164954792831
Gc6_381 0 n12 ns381 0 0.00191464708482
Gc6_382 0 n12 ns382 0 0.00309965915818
Gc6_383 0 n12 ns383 0 3.09838771112e-05
Gc6_384 0 n12 ns384 0 -5.79321577841e-05
Gc6_385 0 n12 ns385 0 -0.0150844917696
Gc6_386 0 n12 ns386 0 -0.00221217380888
Gc6_387 0 n12 ns387 0 -0.00505440677885
Gc6_388 0 n12 ns388 0 0.00740217618431
Gc6_389 0 n12 ns389 0 -0.0122133446207
Gc6_390 0 n12 ns390 0 -2.34217072083e-05
Gc6_391 0 n12 ns391 0 5.10626864715e-05
Gc6_392 0 n12 ns392 0 -2.40862993117e-06
Gc6_393 0 n12 ns393 0 1.10958355171e-07
Gc6_394 0 n12 ns394 0 -1.76304905486e-07
Gc6_395 0 n12 ns395 0 5.44311623184e-06
Gc6_396 0 n12 ns396 0 2.22688621047e-06
Gc6_397 0 n12 ns397 0 0.000283406522128
Gc6_398 0 n12 ns398 0 -0.000644250977717
Gc6_399 0 n12 ns399 0 -8.33144297642e-07
Gc6_400 0 n12 ns400 0 -5.33479280203e-07
Gc6_401 0 n12 ns401 0 -0.0015126940741
Gc6_402 0 n12 ns402 0 5.18204859245e-05
Gc6_403 0 n12 ns403 0 7.81555448768e-06
Gc6_404 0 n12 ns404 0 -6.46594870904e-06
Gc6_405 0 n12 ns405 0 -0.000217897858866
Gc6_406 0 n12 ns406 0 0.000139108047599
Gc6_407 0 n12 ns407 0 0.00774953899766
Gc6_408 0 n12 ns408 0 0.000517952196589
Gc6_409 0 n12 ns409 0 0.00540803693113
Gc6_410 0 n12 ns410 0 -0.00555598283174
Gc6_411 0 n12 ns411 0 1.40136902105e-05
Gc6_412 0 n12 ns412 0 6.12699166563e-05
Gc6_413 0 n12 ns413 0 -1.39762366761e-05
Gc6_414 0 n12 ns414 0 -1.06880146847e-05
Gc6_415 0 n12 ns415 0 -5.21363304613e-05
Gc6_416 0 n12 ns416 0 -6.46243283338e-05
Gc6_417 0 n12 ns417 0 -0.000381931800077
Gc6_418 0 n12 ns418 0 -0.000103401581768
Gc6_419 0 n12 ns419 0 0.00054817479295
Gc6_420 0 n12 ns420 0 -0.00238988576792
Gc6_421 0 n12 ns421 0 -2.63986384442e-05
Gc6_422 0 n12 ns422 0 -3.92007177348e-05
Gc6_423 0 n12 ns423 0 -6.88070686358e-06
Gc6_424 0 n12 ns424 0 -5.43245497892e-05
Gc6_425 0 n12 ns425 0 5.92318873456e-06
Gc6_426 0 n12 ns426 0 -2.79577183939e-05
Gc6_427 0 n12 ns427 0 -2.44939960612e-06
Gc6_428 0 n12 ns428 0 -1.85672167342e-05
Gc6_429 0 n12 ns429 0 -8.90269604794e-06
Gc6_430 0 n12 ns430 0 -2.42626348544e-05
Gc6_431 0 n12 ns431 0 -7.5792643966e-05
Gc6_432 0 n12 ns432 0 1.43197920689e-05
Gc6_433 0 n12 ns433 0 -9.81686352308e-08
Gc6_434 0 n12 ns434 0 3.30774904185e-06
Gc6_435 0 n12 ns435 0 2.79710223e-05
Gc6_436 0 n12 ns436 0 -1.04767846647e-05
Gc6_437 0 n12 ns437 0 -2.00375189466e-06
Gc6_438 0 n12 ns438 0 5.78089358023e-07
Gc6_439 0 n12 ns439 0 2.78064344213e-05
Gc6_440 0 n12 ns440 0 4.19727488279e-05
Gc6_441 0 n12 ns441 0 4.5150495846e-06
Gc6_442 0 n12 ns442 0 -4.81358419424e-07
Gc6_443 0 n12 ns443 0 5.07399387699e-07
Gc6_444 0 n12 ns444 0 -1.50642868777e-06
Gc6_445 0 n12 ns445 0 1.31593981283e-06
Gc6_446 0 n12 ns446 0 3.31077061206e-06
Gc6_447 0 n12 ns447 0 6.06393914722e-06
Gc6_448 0 n12 ns448 0 -1.0834571622e-05
Gc6_449 0 n12 ns449 0 1.00643039879e-06
Gc6_450 0 n12 ns450 0 -2.94234991196e-06
Gc6_451 0 n12 ns451 0 0.000250997717849
Gc6_452 0 n12 ns452 0 -0.00181353696278
Gc6_453 0 n12 ns453 0 0.000738458354712
Gc6_454 0 n12 ns454 0 -6.14871588941e-05
Gc6_455 0 n12 ns455 0 -1.54290478841e-05
Gc6_456 0 n12 ns456 0 -6.97385381051e-05
Gc6_457 0 n12 ns457 0 -0.000111174611038
Gc6_458 0 n12 ns458 0 1.87775183209e-05
Gc6_459 0 n12 ns459 0 -1.56702445474e-08
Gc6_460 0 n12 ns460 0 2.03523131185e-08
Gc6_461 0 n12 ns461 0 2.76562758246e-05
Gc6_462 0 n12 ns462 0 2.30093515981e-05
Gc6_463 0 n12 ns463 0 5.82573265101e-05
Gc6_464 0 n12 ns464 0 3.06474943518e-05
Gc6_465 0 n12 ns465 0 0.000101413992719
Gc6_466 0 n12 ns466 0 -5.91125335879e-05
Gc6_467 0 n12 ns467 0 -3.97476302457e-05
Gc6_468 0 n12 ns468 0 -0.000178101365763
Gc6_469 0 n12 ns469 0 0.000162355136138
Gc6_470 0 n12 ns470 0 -1.60970556825e-05
Gc6_471 0 n12 ns471 0 1.05391533485e-05
Gc6_472 0 n12 ns472 0 -9.47936875292e-05
Gc6_473 0 n12 ns473 0 0.000295309853417
Gc6_474 0 n12 ns474 0 7.87696631691e-05
Gc6_475 0 n12 ns475 0 5.25803741952e-06
Gc6_476 0 n12 ns476 0 -2.38424142764e-05
Gc6_477 0 n12 ns477 0 0.000110430849483
Gc6_478 0 n12 ns478 0 -5.68358379472e-05
Gc6_479 0 n12 ns479 0 0.000220007351259
Gc6_480 0 n12 ns480 0 -0.000302208456021
Gc6_481 0 n12 ns481 0 -2.15499447404e-06
Gc6_482 0 n12 ns482 0 -1.90316571955e-06
Gc6_483 0 n12 ns483 0 6.48913475097e-06
Gc6_484 0 n12 ns484 0 -9.39473086968e-06
Gc6_485 0 n12 ns485 0 0.000127471970267
Gc6_486 0 n12 ns486 0 -0.000259876666588
Gc6_487 0 n12 ns487 0 -1.62381686672e-05
Gc6_488 0 n12 ns488 0 2.64545327456e-05
Gc6_489 0 n12 ns489 0 9.80871004081e-05
Gc6_490 0 n12 ns490 0 6.57258141874e-05
Gc6_491 0 n12 ns491 0 0.0008374463019
Gc6_492 0 n12 ns492 0 -0.00102084955203
Gc6_493 0 n12 ns493 0 -9.43422638178e-05
Gc6_494 0 n12 ns494 0 0.000207820451948
Gc6_495 0 n12 ns495 0 -4.52626425781e-06
Gc6_496 0 n12 ns496 0 1.55206415335e-06
Gc6_497 0 n12 ns497 0 5.86020427856e-05
Gc6_498 0 n12 ns498 0 -0.000135297479178
Gc6_499 0 n12 ns499 0 -2.32488306239e-05
Gc6_500 0 n12 ns500 0 -9.05846779372e-05
Gc6_501 0 n12 ns501 0 0.000193968906756
Gc6_502 0 n12 ns502 0 -0.000153759229288
Gc6_503 0 n12 ns503 0 -0.000172414961938
Gc6_504 0 n12 ns504 0 -0.000245772496524
Gc6_505 0 n12 ns505 0 5.74219776181e-05
Gc6_506 0 n12 ns506 0 -0.000820258273062
Gc6_507 0 n12 ns507 0 7.10618634945e-05
Gc6_508 0 n12 ns508 0 -7.68052469534e-06
Gc6_509 0 n12 ns509 0 5.05890690186e-05
Gc6_510 0 n12 ns510 0 4.58020750912e-05
Gc6_511 0 n12 ns511 0 3.81543096576e-05
Gc6_512 0 n12 ns512 0 -0.000305766169384
Gc6_513 0 n12 ns513 0 -0.00100458519597
Gc6_514 0 n12 ns514 0 -0.000550987949667
Gc6_515 0 n12 ns515 0 -8.99978907765e-06
Gc6_516 0 n12 ns516 0 6.73488083373e-07
Gc6_517 0 n12 ns517 0 2.53706579943e-05
Gc6_518 0 n12 ns518 0 -4.05902261499e-05
Gc6_519 0 n12 ns519 0 1.23488187527e-06
Gc6_520 0 n12 ns520 0 -4.5908920877e-07
Gc6_521 0 n12 ns521 0 -3.28742317898e-05
Gc6_522 0 n12 ns522 0 -0.00013417644274
Gc6_523 0 n12 ns523 0 -9.93589413816e-05
Gc6_524 0 n12 ns524 0 -0.000224362067156
Gc6_525 0 n12 ns525 0 7.93830333637e-06
Gc6_526 0 n12 ns526 0 -9.6806591179e-06
Gc6_527 0 n12 ns527 0 4.2320071918e-05
Gc6_528 0 n12 ns528 0 5.54515416646e-05
Gc6_529 0 n12 ns529 0 0.000127245227624
Gc6_530 0 n12 ns530 0 -8.44543513921e-05
Gc6_531 0 n12 ns531 0 -0.000703205298558
Gc6_532 0 n12 ns532 0 -0.00136952577369
Gc6_533 0 n12 ns533 0 -3.33636609824e-05
Gc6_534 0 n12 ns534 0 3.83662567385e-05
Gc6_535 0 n12 ns535 0 -0.0162465276329
Gc6_536 0 n12 ns536 0 0.0123805339537
Gc6_537 0 n12 ns537 0 0.00580324338142
Gc6_538 0 n12 ns538 0 0.00647756226978
Gc6_539 0 n12 ns539 0 -0.0148088703106
Gc6_540 0 n12 ns540 0 2.55123197622e-05
Gc6_541 0 n12 ns541 0 -2.94022055901e-05
Gc6_542 0 n12 ns542 0 2.92870275849e-05
Gc6_543 0 n12 ns543 0 8.83479830622e-08
Gc6_544 0 n12 ns544 0 6.96931936278e-08
Gc6_545 0 n12 ns545 0 -8.98010762368e-06
Gc6_546 0 n12 ns546 0 -1.16015201624e-05
Gc6_547 0 n12 ns547 0 8.20849481205e-05
Gc6_548 0 n12 ns548 0 -0.000901717777224
Gc6_549 0 n12 ns549 0 1.01491546296e-06
Gc6_550 0 n12 ns550 0 1.59061622762e-07
Gc6_551 0 n12 ns551 0 0.00214064638677
Gc6_552 0 n12 ns552 0 0.0003841271059
Gc6_553 0 n12 ns553 0 7.4940028949e-07
Gc6_554 0 n12 ns554 0 3.23481520918e-06
Gc6_555 0 n12 ns555 0 -0.00025971562961
Gc6_556 0 n12 ns556 0 0.000115670515817
Gc6_557 0 n12 ns557 0 -0.00315006082142
Gc6_558 0 n12 ns558 0 -0.000797560922734
Gc6_559 0 n12 ns559 0 -0.00433434951763
Gc6_560 0 n12 ns560 0 0.00317079942164
Gc6_561 0 n12 ns561 0 7.96838744457e-05
Gc6_562 0 n12 ns562 0 4.28162407909e-06
Gc6_563 0 n12 ns563 0 -1.54332765613e-05
Gc6_564 0 n12 ns564 0 6.73565698635e-06
Gc6_565 0 n12 ns565 0 -1.85539247168e-05
Gc6_566 0 n12 ns566 0 -3.79982938188e-05
Gc6_567 0 n12 ns567 0 0.00021519806297
Gc6_568 0 n12 ns568 0 0.000202893214377
Gc6_569 0 n12 ns569 0 -0.00122625905844
Gc6_570 0 n12 ns570 0 -0.00212702695006
Gc6_571 0 n12 ns571 0 2.9673483382e-05
Gc6_572 0 n12 ns572 0 -8.93545308867e-05
Gc6_573 0 n12 ns573 0 -1.71855498627e-05
Gc6_574 0 n12 ns574 0 6.96245470157e-06
Gc6_575 0 n12 ns575 0 -1.78323999089e-05
Gc6_576 0 n12 ns576 0 9.00169105508e-06
Gc6_577 0 n12 ns577 0 -4.27226459289e-07
Gc6_578 0 n12 ns578 0 2.66054336852e-05
Gc6_579 0 n12 ns579 0 -2.26453116421e-05
Gc6_580 0 n12 ns580 0 -1.89530592882e-06
Gc6_581 0 n12 ns581 0 2.97648828753e-05
Gc6_582 0 n12 ns582 0 1.72169030337e-05
Gc6_583 0 n12 ns583 0 6.46834712461e-06
Gc6_584 0 n12 ns584 0 -2.59245190453e-05
Gc6_585 0 n12 ns585 0 -3.39155818332e-05
Gc6_586 0 n12 ns586 0 1.72364895663e-05
Gc6_587 0 n12 ns587 0 2.34391868308e-07
Gc6_588 0 n12 ns588 0 4.9975287684e-08
Gc6_589 0 n12 ns589 0 5.30820400211e-06
Gc6_590 0 n12 ns590 0 -9.43723404569e-07
Gc6_591 0 n12 ns591 0 -3.62675238078e-06
Gc6_592 0 n12 ns592 0 3.46081349181e-06
Gc6_593 0 n12 ns593 0 -2.16733677457e-07
Gc6_594 0 n12 ns594 0 8.59769019672e-07
Gc6_595 0 n12 ns595 0 5.61995100847e-07
Gc6_596 0 n12 ns596 0 2.22380590727e-07
Gc6_597 0 n12 ns597 0 5.57299766334e-06
Gc6_598 0 n12 ns598 0 7.63288634899e-08
Gc6_599 0 n12 ns599 0 8.97989479103e-07
Gc6_600 0 n12 ns600 0 -8.82514703195e-07
Gc6_601 0 n12 ns601 0 -0.000519493354901
Gc6_602 0 n12 ns602 0 0.00376582229968
Gc6_603 0 n12 ns603 0 -0.000290725202021
Gc6_604 0 n12 ns604 0 5.40085179911e-05
Gc6_605 0 n12 ns605 0 5.78097593712e-05
Gc6_606 0 n12 ns606 0 -0.000146576141249
Gc6_607 0 n12 ns607 0 -1.33782030657e-05
Gc6_608 0 n12 ns608 0 -2.48834362633e-05
Gc6_609 0 n12 ns609 0 9.56535938864e-08
Gc6_610 0 n12 ns610 0 8.97166033757e-08
Gc6_611 0 n12 ns611 0 -9.15704798959e-05
Gc6_612 0 n12 ns612 0 7.49244734747e-05
Gc6_613 0 n12 ns613 0 -0.000102595966109
Gc6_614 0 n12 ns614 0 -5.1135911876e-05
Gc6_615 0 n12 ns615 0 -6.6495059056e-05
Gc6_616 0 n12 ns616 0 -1.34789454912e-05
Gc6_617 0 n12 ns617 0 -0.000127797701988
Gc6_618 0 n12 ns618 0 -5.24643893969e-05
Gc6_619 0 n12 ns619 0 1.38644759937e-07
Gc6_620 0 n12 ns620 0 4.93539403934e-06
Gc6_621 0 n12 ns621 0 5.10832264307e-05
Gc6_622 0 n12 ns622 0 1.87397097317e-05
Gc6_623 0 n12 ns623 0 -0.000380078824139
Gc6_624 0 n12 ns624 0 0.000444089776358
Gc6_625 0 n12 ns625 0 9.562036774e-06
Gc6_626 0 n12 ns626 0 5.56793708329e-06
Gc6_627 0 n12 ns627 0 -2.72009560831e-05
Gc6_628 0 n12 ns628 0 -8.96262180623e-05
Gc6_629 0 n12 ns629 0 -0.000121340846667
Gc6_630 0 n12 ns630 0 -0.000208679284248
Gc6_631 0 n12 ns631 0 4.48893107298e-07
Gc6_632 0 n12 ns632 0 -3.41302904507e-06
Gc6_633 0 n12 ns633 0 -3.95491295531e-06
Gc6_634 0 n12 ns634 0 -5.77565858902e-07
Gc6_635 0 n12 ns635 0 6.86523668703e-05
Gc6_636 0 n12 ns636 0 0.000435040634414
Gc6_637 0 n12 ns637 0 -5.94982247655e-06
Gc6_638 0 n12 ns638 0 -2.76221549654e-05
Gc6_639 0 n12 ns639 0 3.3909637778e-06
Gc6_640 0 n12 ns640 0 1.6208229942e-05
Gc6_641 0 n12 ns641 0 -0.000954849597787
Gc6_642 0 n12 ns642 0 0.000127436595005
Gc6_643 0 n12 ns643 0 5.97714584984e-05
Gc6_644 0 n12 ns644 0 3.22325070387e-05
Gc6_645 0 n12 ns645 0 -1.38577488148e-06
Gc6_646 0 n12 ns646 0 -2.01913852382e-06
Gc6_647 0 n12 ns647 0 0.000129724607253
Gc6_648 0 n12 ns648 0 9.67372956557e-07
Gc6_649 0 n12 ns649 0 2.25438804479e-05
Gc6_650 0 n12 ns650 0 1.9186475241e-05
Gc6_651 0 n12 ns651 0 9.18927774943e-07
Gc6_652 0 n12 ns652 0 0.000165546185426
Gc6_653 0 n12 ns653 0 1.33507551986e-05
Gc6_654 0 n12 ns654 0 0.000187556182431
Gc6_655 0 n12 ns655 0 -0.000530893952837
Gc6_656 0 n12 ns656 0 0.000587615674334
Gc6_657 0 n12 ns657 0 -1.38559257989e-05
Gc6_658 0 n12 ns658 0 -2.5358474677e-05
Gc6_659 0 n12 ns659 0 9.79798408805e-06
Gc6_660 0 n12 ns660 0 -3.11780839669e-05
Gc6_661 0 n12 ns661 0 -0.000154802378385
Gc6_662 0 n12 ns662 0 4.84428471291e-05
Gc6_663 0 n12 ns663 0 -0.000378651759659
Gc6_664 0 n12 ns664 0 -0.000174070284313
Gc6_665 0 n12 ns665 0 -4.12001191771e-06
Gc6_666 0 n12 ns666 0 -4.91416683565e-06
Gc6_667 0 n12 ns667 0 3.86556908389e-05
Gc6_668 0 n12 ns668 0 -5.84676619888e-05
Gc6_669 0 n12 ns669 0 1.06366090428e-06
Gc6_670 0 n12 ns670 0 2.74788471065e-07
Gc6_671 0 n12 ns671 0 -0.000831263071464
Gc6_672 0 n12 ns672 0 0.000347630562705
Gc6_673 0 n12 ns673 0 4.616452369e-05
Gc6_674 0 n12 ns674 0 0.00082851531568
Gc6_675 0 n12 ns675 0 -4.1224183433e-06
Gc6_676 0 n12 ns676 0 -8.88247253857e-06
Gc6_677 0 n12 ns677 0 -0.000156080650864
Gc6_678 0 n12 ns678 0 -9.41360466431e-05
Gc6_679 0 n12 ns679 0 -0.000195664213906
Gc6_680 0 n12 ns680 0 0.00018729355275
Gc6_681 0 n12 ns681 0 -0.00203075888875
Gc6_682 0 n12 ns682 0 0.00196302823894
Gc6_683 0 n12 ns683 0 3.48453477213e-05
Gc6_684 0 n12 ns684 0 -2.03829896887e-05
Gc6_685 0 n12 ns685 0 0.0410210963436
Gc6_686 0 n12 ns686 0 0.0164993106032
Gc6_687 0 n12 ns687 0 -0.0104999567653
Gc6_688 0 n12 ns688 0 0.0112372931046
Gc6_689 0 n12 ns689 0 0.00731613005829
Gc6_690 0 n12 ns690 0 -0.000132066004809
Gc6_691 0 n12 ns691 0 2.68737116711e-05
Gc6_692 0 n12 ns692 0 1.41651939684e-05
Gc6_693 0 n12 ns693 0 2.367950515e-07
Gc6_694 0 n12 ns694 0 2.53477105652e-07
Gc6_695 0 n12 ns695 0 5.74240041127e-06
Gc6_696 0 n12 ns696 0 1.11150822279e-06
Gc6_697 0 n12 ns697 0 0.000605691995996
Gc6_698 0 n12 ns698 0 0.000281778452717
Gc6_699 0 n12 ns699 0 -1.21156148811e-06
Gc6_700 0 n12 ns700 0 -2.94065125191e-07
Gc6_701 0 n12 ns701 0 -0.00360823651559
Gc6_702 0 n12 ns702 0 -0.0010285997745
Gc6_703 0 n12 ns703 0 5.23160718484e-05
Gc6_704 0 n12 ns704 0 -4.92365077767e-06
Gc6_705 0 n12 ns705 0 -0.000152719535006
Gc6_706 0 n12 ns706 0 8.06275400073e-05
Gc6_707 0 n12 ns707 0 -0.00114496026538
Gc6_708 0 n12 ns708 0 0.0100183682402
Gc6_709 0 n12 ns709 0 0.00880224735397
Gc6_710 0 n12 ns710 0 0.0156722736019
Gc6_711 0 n12 ns711 0 -3.42832912298e-05
Gc6_712 0 n12 ns712 0 5.9102034744e-05
Gc6_713 0 n12 ns713 0 3.1296364849e-06
Gc6_714 0 n12 ns714 0 -1.07032778202e-05
Gc6_715 0 n12 ns715 0 -2.06995586316e-05
Gc6_716 0 n12 ns716 0 -9.65974075109e-05
Gc6_717 0 n12 ns717 0 -0.000129546746016
Gc6_718 0 n12 ns718 0 -0.000290559140368
Gc6_719 0 n12 ns719 0 0.00241588034946
Gc6_720 0 n12 ns720 0 0.00176799648969
Gc6_721 0 n12 ns721 0 -2.53493754805e-06
Gc6_722 0 n12 ns722 0 -6.73221931474e-06
Gc6_723 0 n12 ns723 0 1.02992530015e-05
Gc6_724 0 n12 ns724 0 -1.80186962301e-05
Gc6_725 0 n12 ns725 0 2.2751389914e-05
Gc6_726 0 n12 ns726 0 -1.03400631769e-05
Gc6_727 0 n12 ns727 0 -4.70134786598e-07
Gc6_728 0 n12 ns728 0 -1.08079624262e-05
Gc6_729 0 n12 ns729 0 -6.57217963131e-06
Gc6_730 0 n12 ns730 0 -2.2100688614e-05
Gc6_731 0 n12 ns731 0 -6.09448262416e-05
Gc6_732 0 n12 ns732 0 -2.16963231882e-05
Gc6_733 0 n12 ns733 0 1.08687289159e-06
Gc6_734 0 n12 ns734 0 5.17762044518e-06
Gc6_735 0 n12 ns735 0 2.39166295765e-05
Gc6_736 0 n12 ns736 0 -1.59424673897e-06
Gc6_737 0 n12 ns737 0 2.92968963079e-07
Gc6_738 0 n12 ns738 0 -2.87705650462e-08
Gc6_739 0 n12 ns739 0 -7.83536936384e-07
Gc6_740 0 n12 ns740 0 -1.60537526382e-05
Gc6_741 0 n12 ns741 0 -5.10378364007e-07
Gc6_742 0 n12 ns742 0 -8.68501558383e-06
Gc6_743 0 n12 ns743 0 -1.25157478909e-06
Gc6_744 0 n12 ns744 0 -2.07891799766e-06
Gc6_745 0 n12 ns745 0 2.34189954096e-06
Gc6_746 0 n12 ns746 0 -6.21394530191e-06
Gc6_747 0 n12 ns747 0 -4.8099944689e-06
Gc6_748 0 n12 ns748 0 1.16063978037e-06
Gc6_749 0 n12 ns749 0 -2.79861222074e-06
Gc6_750 0 n12 ns750 0 1.48304010612e-06
Gc6_751 0 n12 ns751 0 -0.00689238697964
Gc6_752 0 n12 ns752 0 0.00299196179633
Gc6_753 0 n12 ns753 0 -0.000902619774571
Gc6_754 0 n12 ns754 0 1.2023736122e-05
Gc6_755 0 n12 ns755 0 -7.23885753869e-05
Gc6_756 0 n12 ns756 0 9.60358724132e-06
Gc6_757 0 n12 ns757 0 1.30822902121e-05
Gc6_758 0 n12 ns758 0 -6.45980638513e-05
Gc6_759 0 n12 ns759 0 -2.9256477675e-09
Gc6_760 0 n12 ns760 0 -8.32663401653e-08
Gc6_761 0 n12 ns761 0 -4.27613551863e-05
Gc6_762 0 n12 ns762 0 2.44001677451e-06
Gc6_763 0 n12 ns763 0 6.314095395e-05
Gc6_764 0 n12 ns764 0 -4.50365852037e-05
Gc6_765 0 n12 ns765 0 -1.22418918291e-05
Gc6_766 0 n12 ns766 0 -0.000158462500478
Gc6_767 0 n12 ns767 0 -0.000176400594146
Gc6_768 0 n12 ns768 0 -5.95072531427e-05
Gc6_769 0 n12 ns769 0 4.02773986589e-05
Gc6_770 0 n12 ns770 0 -0.00016401366189
Gc6_771 0 n12 ns771 0 -3.66621914317e-05
Gc6_772 0 n12 ns772 0 -8.87621569976e-05
Gc6_773 0 n12 ns773 0 0.00021363331561
Gc6_774 0 n12 ns774 0 0.000137681618149
Gc6_775 0 n12 ns775 0 2.79075385805e-06
Gc6_776 0 n12 ns776 0 -2.01537984316e-05
Gc6_777 0 n12 ns777 0 3.51088820235e-05
Gc6_778 0 n12 ns778 0 -0.000130850871607
Gc6_779 0 n12 ns779 0 0.000113016771537
Gc6_780 0 n12 ns780 0 -9.68164786428e-05
Gc6_781 0 n12 ns781 0 -3.47596418257e-06
Gc6_782 0 n12 ns782 0 1.89164265789e-06
Gc6_783 0 n12 ns783 0 6.26683397482e-06
Gc6_784 0 n12 ns784 0 -1.02699970137e-05
Gc6_785 0 n12 ns785 0 0.000149930720386
Gc6_786 0 n12 ns786 0 -0.000338134200303
Gc6_787 0 n12 ns787 0 -1.17422493228e-05
Gc6_788 0 n12 ns788 0 2.24329952044e-05
Gc6_789 0 n12 ns789 0 0.000102734849825
Gc6_790 0 n12 ns790 0 4.74612541453e-05
Gc6_791 0 n12 ns791 0 0.000363199535675
Gc6_792 0 n12 ns792 0 -0.00136071129348
Gc6_793 0 n12 ns793 0 3.30577143406e-07
Gc6_794 0 n12 ns794 0 0.000234020091126
Gc6_795 0 n12 ns795 0 -8.74037457175e-06
Gc6_796 0 n12 ns796 0 1.51106268384e-07
Gc6_797 0 n12 ns797 0 -1.29649621007e-05
Gc6_798 0 n12 ns798 0 -7.88624836474e-05
Gc6_799 0 n12 ns799 0 -6.34749046268e-05
Gc6_800 0 n12 ns800 0 -6.90777632682e-05
Gc6_801 0 n12 ns801 0 0.000127656498913
Gc6_802 0 n12 ns802 0 -0.0002983784487
Gc6_803 0 n12 ns803 0 -0.000304668725132
Gc6_804 0 n12 ns804 0 -0.000241914534111
Gc6_805 0 n12 ns805 0 -0.000209521000409
Gc6_806 0 n12 ns806 0 -0.000722169180402
Gc6_807 0 n12 ns807 0 7.28880397184e-05
Gc6_808 0 n12 ns808 0 -4.83322436813e-05
Gc6_809 0 n12 ns809 0 5.81594235408e-05
Gc6_810 0 n12 ns810 0 2.42756694278e-05
Gc6_811 0 n12 ns811 0 -5.20978699808e-05
Gc6_812 0 n12 ns812 0 -0.000290466028502
Gc6_813 0 n12 ns813 0 -0.000872221917533
Gc6_814 0 n12 ns814 0 -0.000362212849065
Gc6_815 0 n12 ns815 0 -2.3718020813e-06
Gc6_816 0 n12 ns816 0 -3.73445023251e-07
Gc6_817 0 n12 ns817 0 3.51751950204e-05
Gc6_818 0 n12 ns818 0 -4.18026477673e-05
Gc6_819 0 n12 ns819 0 1.46410024183e-06
Gc6_820 0 n12 ns820 0 -1.76746479344e-07
Gc6_821 0 n12 ns821 0 -0.000273413697564
Gc6_822 0 n12 ns822 0 -0.000375145442497
Gc6_823 0 n12 ns823 0 -0.000245371548164
Gc6_824 0 n12 ns824 0 -5.74817131714e-05
Gc6_825 0 n12 ns825 0 -7.70027769002e-07
Gc6_826 0 n12 ns826 0 -1.72491873544e-05
Gc6_827 0 n12 ns827 0 1.1604929194e-05
Gc6_828 0 n12 ns828 0 5.77101934697e-05
Gc6_829 0 n12 ns829 0 0.000111532217755
Gc6_830 0 n12 ns830 0 -5.02862855209e-05
Gc6_831 0 n12 ns831 0 -0.00141247611209
Gc6_832 0 n12 ns832 0 -0.000400637476427
Gc6_833 0 n12 ns833 0 -1.99474497994e-05
Gc6_834 0 n12 ns834 0 4.44863079634e-05
Gc6_835 0 n12 ns835 0 -0.0187465727175
Gc6_836 0 n12 ns836 0 0.0106577470074
Gc6_837 0 n12 ns837 0 0.00755619999871
Gc6_838 0 n12 ns838 0 0.00974449611873
Gc6_839 0 n12 ns839 0 -0.0135576111275
Gc6_840 0 n12 ns840 0 0.00010099492349
Gc6_841 0 n12 ns841 0 -2.35130191507e-05
Gc6_842 0 n12 ns842 0 3.58586094168e-05
Gc6_843 0 n12 ns843 0 -3.23062632058e-08
Gc6_844 0 n12 ns844 0 9.60874958876e-08
Gc6_845 0 n12 ns845 0 -1.0939066789e-05
Gc6_846 0 n12 ns846 0 -7.18460536181e-06
Gc6_847 0 n12 ns847 0 -0.000282969262747
Gc6_848 0 n12 ns848 0 -0.000469953458463
Gc6_849 0 n12 ns849 0 5.93058215974e-07
Gc6_850 0 n12 ns850 0 -8.97199638236e-07
Gc6_851 0 n12 ns851 0 0.00136614266155
Gc6_852 0 n12 ns852 0 0.00129835739228
Gc6_853 0 n12 ns853 0 8.34257683097e-07
Gc6_854 0 n12 ns854 0 -2.05386614572e-05
Gc6_855 0 n12 ns855 0 -0.000225720586361
Gc6_856 0 n12 ns856 0 0.000191045783178
Gc6_857 0 n12 ns857 0 -0.00245293202059
Gc6_858 0 n12 ns858 0 6.9942990191e-05
Gc6_859 0 n12 ns859 0 -0.00302287870129
Gc6_860 0 n12 ns860 0 0.00141683416384
Gc6_861 0 n12 ns861 0 5.79555522023e-05
Gc6_862 0 n12 ns862 0 -9.71395823769e-06
Gc6_863 0 n12 ns863 0 -1.42857864638e-05
Gc6_864 0 n12 ns864 0 5.56995598842e-07
Gc6_865 0 n12 ns865 0 -3.99993852773e-05
Gc6_866 0 n12 ns866 0 -5.27026065928e-05
Gc6_867 0 n12 ns867 0 0.000282614996768
Gc6_868 0 n12 ns868 0 0.000113720341043
Gc6_869 0 n12 ns869 0 -0.000388395389959
Gc6_870 0 n12 ns870 0 -0.000706076765346
Gc6_871 0 n12 ns871 0 4.78219293793e-05
Gc6_872 0 n12 ns872 0 -8.35538298128e-05
Gc6_873 0 n12 ns873 0 -1.59885200029e-05
Gc6_874 0 n12 ns874 0 2.19322005032e-05
Gc6_875 0 n12 ns875 0 -1.4075085977e-05
Gc6_876 0 n12 ns876 0 1.88576593068e-05
Gc6_877 0 n12 ns877 0 -1.55997665019e-06
Gc6_878 0 n12 ns878 0 3.60232043009e-05
Gc6_879 0 n12 ns879 0 -3.4572597235e-05
Gc6_880 0 n12 ns880 0 4.98936618778e-06
Gc6_881 0 n12 ns881 0 1.93811688528e-05
Gc6_882 0 n12 ns882 0 -5.67577495359e-06
Gc6_883 0 n12 ns883 0 4.17783449711e-06
Gc6_884 0 n12 ns884 0 -3.38181849986e-05
Gc6_885 0 n12 ns885 0 -4.09524388659e-05
Gc6_886 0 n12 ns886 0 2.62356466956e-05
Gc6_887 0 n12 ns887 0 7.74819731026e-07
Gc6_888 0 n12 ns888 0 3.83787348385e-07
Gc6_889 0 n12 ns889 0 8.41175179254e-06
Gc6_890 0 n12 ns890 0 5.02119220232e-06
Gc6_891 0 n12 ns891 0 -3.45331949515e-06
Gc6_892 0 n12 ns892 0 -1.13497834298e-06
Gc6_893 0 n12 ns893 0 -9.26608352864e-07
Gc6_894 0 n12 ns894 0 -8.69432476738e-08
Gc6_895 0 n12 ns895 0 3.06876273247e-06
Gc6_896 0 n12 ns896 0 -2.17592491439e-06
Gc6_897 0 n12 ns897 0 3.28044824246e-06
Gc6_898 0 n12 ns898 0 -1.71195968743e-06
Gc6_899 0 n12 ns899 0 -1.48301498611e-07
Gc6_900 0 n12 ns900 0 -2.75236424982e-06
Gd6_1 0 n12 ni1 0 0.00100552128407
Gd6_2 0 n12 ni2 0 0.000624662234596
Gd6_3 0 n12 ni3 0 0.000541755845258
Gd6_4 0 n12 ni4 0 0.00155155503623
Gd6_5 0 n12 ni5 0 0.000224939503148
Gd6_6 0 n12 ni6 0 -0.00808739803305
.ends SSN_1_5_ssn_sp
