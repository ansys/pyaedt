# Ansys Electronics Desktop project, version 2025.1
materials:
  vacuum: permittivity=1
  pec: conductivity=1e+30

design point_cloud_generator (HFSS, SBR+, model units mm)
geometry:
  RegularPolyhedron1 [vacuum] = polyhedron(axis=Z, centre=(-1.8mm, 0.6mm, 0mm), first_corner=(-1.2mm, 0.4mm, 0mm), sides=12, height=0.8mm)
  Torus1 [vacuum] = torus(axis=Z, centre=(1mm, -0.6mm, 0mm), major_radius=0.91529824mm, minor_radius=0.34961282mm)
  Polygon1 = regular_polygon(axis=Z, centre=(0.2mm, 2.4mm, 0mm), first_corner=(1.2mm, 2.2mm, 0mm), sides=12)
  Antenna1_1 = component(Antenna1, Type="Linked Antenna" Unit=mm LinkID=18 Project="This Project*" Product=HFSS Design=WireDipole_ATK Params{Airbox_dist=4.1638cm Huygens_dist=3.331cm dipole_length=14.99cm port_gap=0.25cm wire_rad=0.25cm} PathRelativeTo=TargetProject BlockageLinkID=19 VisualizationLinkID=20 StructureLinkID=21 FieldType=farfield BoundingBoxID=6 BoundingBoxLowPoint(-0.0774767, -0.0774767, -0.149927) BoundingBoxHighPoint(0.0774767, 0.0774767, 0.149927) PortInfo{1{Faces(33) Modes{Mode1{CharImp=Zpi}} Impedance=50ohm}} PortDefinitionIDs(0) DomainInfo{DomainPorts(0)})
  Antenna1_Footprint [non-model] = part_of(Antenna1_1)
boundaries and excitations:
  Antenna1_1_1: Proxy Port Objects=Antenna1_Footprint DefinitionPortID=0 DefinitionPortName=1 DefinitionPortType=4 NumModes=1 PortImpedance=50ohm Modes{Mode1{CharImp=Zpi}} RenormalizeAllTerminals=false
source amplitudes:
  Antenna1_1_1:1: 1W 0deg

design WireDipole_ATK (HFSS, HFSS Hybrid Terminal Network, model units cm)
options: Allow_Material_Override Save_Adaptive_support_files
variables:
  # --Antenna Dimensions
  dipole_length = 14.99cm
  wire_rad = 0.25cm
  port_gap = 0.25cm
  # --Radiating Surface
  Huygens_dist = 3.331cm
  Airbox_dist = 4.1638cm
geometry:
  arm1 [pec] = cylinder(axis=Z, base_centre=(0cm, 0cm, port_gap/2), radius=wire_rad, height=dipole_length/2-port_gap/2)
  arm1_1 [pec] = arm1.duplicate_around_axis(axis=X, angle=180deg, total=2)
  port1 = rectangle(corner=(0cm, -wire_rad, -port_gap/2), y_size=wire_rad*2, z_size=port_gap)
  HuygensBox [vacuum] = box(corner=(-wire_rad - Huygens_dist, -wire_rad - Huygens_dist, -(dipole_length/2) - Huygens_dist), size=(abs(-wire_rad - wire_rad) + 2*Huygens_dist, abs(-wire_rad - wire_rad) + 2*Huygens_dist, abs(-(dipole_length/2) - dipole_length/2) + 2*Huygens_dist))
  RadiatingSurface [vacuum] = region(absolute_offset=4.1666667cm on all sides)
boundaries and excitations:
  AutoOpen1: FE-BI Objects=RadiatingSurface UseAdaptiveIE
  port1_T1: Terminal port=1 Edges=port1.edge(at (0, 0, -0.125)) TerminalResistance=50ohm
  1: Lumped Port Faces=port1.face LumpedPortType=Terminal Impedance=50ohm
  reference conductors: arm1
mesh:
  HuygensBox_Seed: LengthBased Objects=HuygensBox MaxLength=3.331cm
setups:
  ATK_Solution: HfssDriven Frequency=0.9GHz MaxDeltaS=0.02 MaximumPasses=15 MinimumPasses=1 MinimumConvergedPasses=1 PercentRefinement=30 BasisOrder=1 PortAccuracy=2 DrivenSolverType="Domain Decomposition" IterativeResidual=1e-06 DDMSolverResidual=0.0001 IESolverType=ACA
    sweep FF_Sweep: 0.45GHz to 1.35GHz, 3 points; Type=Discrete SaveFields
    sweep SParam_Sweep: 0.45GHz to 1.35GHz, 100 points; Type=Interpolating InterpTolerance=0.5 InterpMaxSolns=250 PassivityErrorTolerance=0.0001
source amplitudes:
  1:1: 1V 0deg
radiation setups:
  3D: Infinite Sphere Theta=0deg..180deg step 2deg Phi=-180deg..180deg step 2deg
  Elevation: Infinite Sphere Theta=-180deg..180deg step 1deg Phi=0deg..90deg step 90deg
  Azimuth: Infinite Sphere Theta=90deg..90deg step 0deg Phi=-180deg..180deg step 1deg
  ATK_2D: Infinite Sphere Theta=-180deg..180deg step 1deg Phi=0deg..90deg step 90deg
  ATK_3D: Infinite Sphere Theta=-180deg..180deg step 2deg Phi=0deg..180deg step 5deg
reports:
  ff_3D_GainTotal: dB(GainTotal) vs Phi, Theta on ATK_Solution : LastAdaptive, ATK_3D [Freq=9e+08]
  ff_2D_GainTotal: dB(GainTotal) vs Theta on ATK_Solution : LastAdaptive, ATK_2D [Phi=all Freq=9e+08]
  ff_2D_GainTotal_Stacked: dB(GainTotal) vs Theta on ATK_Solution : FF_Sweep, ATK_2D [Phi=all Freq=all]
  Return Loss: dB(St11) vs Freq on ATK_Solution : SParam_Sweep
  Input Impedance: St11 on ATK_Solution : SParam_Sweep [Freq=all]
