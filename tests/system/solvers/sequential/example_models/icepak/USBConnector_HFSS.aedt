# Ansys Electronics Desktop project, version 2024.2
project datasets:
  $ds1: (22, 1) (200, 0.6)
materials:
  COPPER: thermal_modifier{Property=conductivity free_form_value=pwl($ds1,Temp)} conductivity=59590000
  Teflon (tm): permittivity=2.1 dielectric_loss_tangent=0.001
  vacuum: permittivity=1
  Al-Extruded
  air: permittivity=1.0006 permeability=1.0000004
surface materials:
  Steel-oxidised-surface

design uUSB (HFSS, HFSS Terminal Network, model units mm)
options: Calculate_Lossy_Dielectrics Save_Adaptive_support_files
geometry:
  coordinate_system RelativeCS1 = origin=(-1.71mm, -3.55mm, -15.47912mm) x=(1mm, 0mm, 0mm) y=(0mm, 1mm, 0mm)
  Rectangle3 = rectangle(corner=(1.42mm, 1.5mm, 3.4291458mm), x_size=0.715mm, y_size=-0.4mm)
  Rectangle3.move(-1.86mm, -4.975mm, -15.173562mm)
  RadiatingSurface [vacuum] = region(absolute_offset=5.0161461mm on all sides)
  Rectangle3.rotate(axis=Y, angle=90deg) in RelativeCS1
  Rectangle3.rotate(axis=Y, angle=180deg)
  Rectangle3.rotate(axis=Z, angle=90deg)
  coordinate_system RelativeCS2 = origin=(-1.71mm, -3.55mm, -15.47912mm) x=(1mm, 0mm, 0mm) y=(0mm, 1mm, 0mm)
  Rectangle3.move(49.318575mm, -5.6356908mm, -12.99458mm)
  Rectangle3.move(0mm, 5mm, 0mm)
  coordinate_system RelativeCS4 = origin=(-1.71mm, -3.55mm, -15.47912mm) x=(1mm, 0mm, 0mm) y=(0mm, 1mm, 0mm)
  coordinate_system RelativeCS5 = origin=(-1.71mm, -3.55mm, -15.47912mm) x=(1mm, 0mm, 0mm) y=(0mm, 1mm, 0mm)
  Rectangle3.move(-3.492136mm, -0.93699965mm, -0.34826mm)
  Rectangle3.delete()
  USB_VCC, USB_ID, USB_GND, usb_N, usb_P, USB_Shiels [COPPER] = imported_body()
  USBmale_ObjectFromFace1 [Teflon (tm)] = imported_body()
  Rectangle1, Rectangle1_1..Rectangle1_4, Rectangle2, Rectangle3_1, Rectangle3_1_1, Rectangle3_1_2, Rectangle3_1_3, Rectangle4..Rectangle7 [vacuum] = imported_body()
  group Group1 = USB_VCC, USB_ID, USB_GND, usb_N, usb_P, USB_Shiels, USBmale_ObjectFromFace1, Rectangle1, Rectangle1_1..Rectangle1_4, Rectangle2, Rectangle3_1, Rectangle3_1_1, Rectangle3_1_2, Rectangle3_1_3, Rectangle4..Rectangle7
boundaries and excitations:
  PerfE1: Perfect E Objects=Rectangle2
  PerfE2: Perfect E Objects=[Rectangle1, Rectangle1_3, Rectangle1_4]
  PerfE3: Perfect E Objects=[Rectangle3_1_3, Rectangle3_1_2]
  PerfE4: Perfect E Objects=[Rectangle5, Rectangle6, Rectangle4, Rectangle7]
  Open1: Radiation Objects=RadiatingSurface
  usb_N_pcb: Terminal port=N_pcb_Port Edges=Rectangle1_1.edge(at (50.1514, -0.0154696, 1.98628)) TerminalResistance=50ohm
  usb_P_pcb: Terminal port=P_pcb_Port Edges=Rectangle1_2.edge(at (49.5014, -0.0154696, 1.98628)) TerminalResistance=50ohm
  usb_N_conn: Terminal port=N_conn_Port Edges=usb_N.edge(at (50.1514, -3.59739, 3.40628)) TerminalResistance=50ohm
  USB_VCC_T1: Terminal port=P_conn_Port Edges=USB_VCC.edge(at (50.8014, -3.59739, 3.40628)) TerminalResistance=50ohm
  N_pcb_Port: Lumped Port Faces=Rectangle1_1.face(at (50.1514, -0.0154696, 1.83628)) LumpedPortType=Terminal Impedance=50ohm
  P_pcb_Port: Lumped Port Faces=Rectangle1_2.face(at (49.5014, -0.0154696, 1.83628)) LumpedPortType=Terminal Impedance=50ohm
  N_conn_Port: Lumped Port Faces=Rectangle3_1.face(at (50.1514, -3.59739, 3.76378)) LumpedPortType=Terminal Impedance=50ohm
  P_conn_Port: Lumped Port Faces=Rectangle3_1_1.face(at (50.8014, -3.59739, 3.76378)) LumpedPortType=Terminal Impedance=50ohm
  reference conductors: USB_Shiels
temperatures:
  USB_VCC, USB_ID, USB_GND, usb_N, usb_P, USB_Shiels, USBmale_ObjectFromFace1, Rectangle1, Rectangle1_1..Rectangle1_4, Rectangle2, Rectangle3_1, Rectangle3_1_1, Rectangle3_1_2, Rectangle3_1_3, Rectangle4..Rectangle7, RadiatingSurface: 22cel
setups:
  Setup1: HfssDriven Frequency=2.5GHz MaxDeltaS=0.02 MaximumPasses=10 MinimumPasses=1 MinimumConvergedPasses=1 PercentRefinement=30 BasisOrder=1 PortAccuracy=2 DrivenSolverType="Direct Solver"
    sweep Sweep: 0GHz to 5GHz step 0.01GHz; disabled Type=Interpolating InterpTolerance=0.5 InterpMaxSolns=250 MinSolvedFreq=0.01GHz PassivityErrorTolerance=0.0001
source amplitudes:
  N_pcb_Port:1, P_pcb_Port:1: 50V 0deg
  N_conn_Port:1, P_conn_Port:1: 0V 0deg
reports:
  XY Plot 1: dB(St(usb_N_pcb,usb_N_conn)) vs Freq on Setup1 : Sweep
