# Ansys Electronics Desktop project, version 2023.1
materials:
  vacuum: permittivity=1
  LCP: permittivity=3.1 dielectric_loss_tangent=0.003
  gold: permeability=0.99996 conductivity=41000000
  teflon_based: permittivity=2.08 dielectric_loss_tangent=0.001
  Teflon (tm): permittivity=2.1 dielectric_loss_tangent=0.001
  perfect conductor: conductivity=1e+30
  FR4_epoxy: permittivity=4.4 dielectric_loss_tangent=0.02
  polyamide: permittivity=4.3 dielectric_loss_tangent=0.004

design Test_ufl (HFSS, HFSS Modal Network, model units mm)
geometry:
  Polyline1 = polyline((1mm, 0mm, 0mm) (30mm, 0mm, 0mm), section line width=1mm)
  Box1 [polyamide] = box(corner=(-15mm, -15mm, 0mm), size=(45mm, 30mm, -0.5mm))
  Box2 [vacuum] = box(corner=(-15mm, -15mm, 0mm), size=(45mm, 30mm, 15mm))
  Polyline2 = polyline((30mm, 0mm, -0.5mm) (30mm, 0mm, 3mm), section line width=8mm)
  Box3 [perfect conductor] = box(corner=(-1.1mm, 1mm, 0mm), size=(2.2mm, 1mm, -0.5mm))
  Box3.duplicate_around_axis(axis=Z, angle=180deg, total=2, attached)
  Box3_1 = Box3.copy()
  Box1.subtract(Box3_1)
  UFL_MHF1_connector_SMT_PCB_and_Cable068_DM1 = component(UFL_MHF1_connector_SMT_PCB_and_Cable068_DM, 3D_Component_File_Path=D:/TEMP_PROJECTS/UFL_MHF1_connector_SMT_PCB_Cable068_DM.a3dcomp, cable_length=2mm, coaxial_connector_angle=180deg)
  Housing [LCP] = part_of(UFL_MHF1_connector_SMT_PCB_and_Cable068_DM1)
  Outer_Contact, Signal_Contact, coaxial_connector_housing, coaxial_connector_signal [gold] = part_of(UFL_MHF1_connector_SMT_PCB_and_Cable068_DM1)
  coaxial_dielectric [Teflon (tm)] = part_of(UFL_MHF1_connector_SMT_PCB_and_Cable068_DM1)
  dummy_cable [perfect conductor] = part_of(UFL_MHF1_connector_SMT_PCB_and_Cable068_DM1)
  coordinate_system RelativeCS1 = origin=(-14mm, 2mm, 0mm) x=(1mm, 0mm, 0mm) y=(0mm, -1mm, 0mm)
  UFL_MHF1_connector_SMT_PCB_and_Cable068_DM2 = component(UFL_MHF1_connector_SMT_PCB_and_Cable068_DM, 3D_Component_File_Path=D:/TEMP_PROJECTS/UFL_MHF1_connector_SMT_PCB_Cable068_DM.a3dcomp, cable_length=2mm, coaxial_connector_angle=180deg)
  Housing2 [LCP] = part_of(UFL_MHF1_connector_SMT_PCB_and_Cable068_DM2) in RelativeCS1
  Outer_Contact2, Signal_Contact2, coaxial_connector_housing2, coaxial_connector_signal2 [gold] = part_of(UFL_MHF1_connector_SMT_PCB_and_Cable068_DM2) in RelativeCS1
  coaxial_dielectric2 [Teflon (tm)] = part_of(UFL_MHF1_connector_SMT_PCB_and_Cable068_DM2) in RelativeCS1
  dummy_cable2 [perfect conductor] = part_of(UFL_MHF1_connector_SMT_PCB_and_Cable068_DM2) in RelativeCS1
boundaries and excitations:
  Rad1: Radiation Faces=Box2.face(+y, +z, -x, -y, +x)
  PerfE1: Perfect E Objects=Polyline1
  PerfE2: Perfect E Faces=Box1.face(-z) InfGroundPlane
  1: Wave Port Faces=Polyline2.face WavePortType=Modal NumModes=1 DeembedDist=38.5mm Modes{Mode1{IntLine{(30, 0, -0.5) -> (30, 0, 0)} CharImp=Zpi}}
  UFL_MHF1_connector_SMT_PCB_and_Cable068_DM1_1: Wave Port Faces=coaxial_dielectric.face(at (-3, 0, 1.85)) WavePortType=Modal NumModes=1 DeembedDist=2.15mm Modes{Mode1{IntLine{(-3, -0.1, 1.85) -> (-3, -0.34, 1.85)} CharImp=Zpi}}
  UFL_MHF1_connector_SMT_PCB_and_Cable068_DM2_1: Wave Port Faces=coaxial_dielectric2.face(at (-17, 2, -1.85)) WavePortType=Modal NumModes=1 DeembedDist=2.15mm Modes{Mode1{IntLine{(-17, 2.1, -1.85) -> (-17, 2.34, -1.85)} CharImp=Zpi}}
mesh:
  initial mesh: GlobalCurvilinear{Apply}
setups:
  Setup1: HfssDriven MultipleAdaptiveFreqsSetup{Low=0.5GHz High=10GHz} MaxDeltaS=0.01 MaximumPasses=15 MinimumPasses=2 MinimumConvergedPasses=2 PercentRefinement=30 BasisOrder=1 PortAccuracy=0.5 DrivenSolverType="Direct Solver" SaveAnyFields=false
    sweep Sweep: 0.5GHz to 10GHz, 476 points; Type=Interpolating InterpTolerance=0.5 InterpMaxSolns=250 InterpUsePortImped=false PassivityErrorTolerance=0.0001
source amplitudes:
  1:1: 1W 0deg
  UFL_MHF1_connector_SMT_PCB_and_Cable068_DM1_1:1, UFL_MHF1_connector_SMT_PCB_and_Cable068_DM2_1:1: 0W 0deg
reports:
  VSWR Plot 1: VSWR(1) vs Freq on Setup1 : Sweep
