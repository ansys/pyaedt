# Ansys Electronics Desktop project, version 2024.2
materials:
  FR4_epoxy: permittivity=4.4 dielectric_loss_tangent=0.02
  aluminum: permeability=1.000021 conductivity=38000000
  vacuum: permittivity=1
  copper: permeability=0.999991 conductivity=58000000
  pec: conductivity=1e+30
  GPS_LTCC2: permittivity=68
  foam: permittivity=0.9 dielectric_loss_tangent=0.002

design ATA_Analysis (HFSS, HFSS Terminal Network, model units mm)
options: Allow_Material_Override Calculate_Lossy_Dielectrics Save_Adaptive_support_files
variables:
  Pz = 2mm
  E1 = 2mm
  E2 = -2mm
  E3 = -2mm
  E4 = 4mm
  short_p = 15mm
  E5 = 2mm
  copper_e = 70um
  laminate = 0.5mm
  aqw = 100
  ITO_X_pitch = 4.5mm
  ITO_Y_pitch = 5mm
  pet1_t = 0.12mm
  pet2_t = 0.12mm
  OCA1_t = 0.05mm
  OCA2_t = 0.1mm
  glass_t = 0.7mm
  X_lines = 16
  Y_lines = 9
  metal_w = 0.1mm
  mp = metal_w*2
  mt = 0.3mm
  mXps = -7mm
  ITO_t = 0.01mm
  metal_t = 0.01mm
  mXd = myd-mp*5
  mXp = cY-mp*7
  cY = ITO_Y_pitch*Y_lines/2
  myd = -1mm
  xrs = ITO_Y_pitch*Y_lines+mt
  mXpr = ITO_Y_pitch*Y_lines-mXp
  ITO_X_w = 4.1mm
  ITO_Y_w = 1.1mm
  finger_X = 5
  finger_Y = 8
  finger_diameter = 5mm
  finger_length = 6mm
  substrate_ysize = 13mm
  substrate_zsize = 2mm
  substrate_xsize = 13mm
  patch_ysize = 12mm
  patch_xsize = 12mm
  coax_inner_pin_radius = 0.167mm
  coax_feed_yoffset = 0.9mm
  coax_feed_xoffset = -0.4mm
  L2 = L1
  W2 = W1
  foam_thickness = 7mm
  L1 = 8.98377mm
  patch_lower_elevation = foam_lower_elevation + foam_thickness
  Ofs_short = 10mm
  W1 = 1.5mm
  foam_lower_elevation = 0mm
  cutoff = 1.1mm
  Ofs_fedY = 6mm
  Ofs_fedX = 1.75mm
  GND_lower_elevation = foam_lower_elevation
geometry:
  coordinate_system RelativeCS62 = origin=(-197.0725mm, -22.605447mm, -2.3280794mm) x=(1mm, 0mm, 0mm) y=(0mm, 1mm, 0mm)
  coordinate_system RelativeCS63 = origin=(3.5mm, 0mm, 25.597691mm) x=(1mm, 0mm, 0mm) y=(0mm, 1mm, 0mm) in RelativeCS62
  coordinate_system RelativeCS64 = origin=(-8.9035866mm, 6.7069888mm, -24.99747mm) x=(1mm, 0mm, 0mm) y=(0mm, 1mm, 0mm) in RelativeCS63
  coordinate_system RelativeCS65 = origin=(4.3mm, -0.01mm, 4.95mm) x=(1mm, 0mm, 0mm) y=(0mm, 1mm, 0mm) in RelativeCS64
  coordinate_system RelativeCS66 = origin=(-1.25mm, 0.18mm, 0.7mm) x=(1mm, 0mm, 0mm) y=(0mm, 1mm, 0mm) in RelativeCS65
  coordinate_system RelativeCS67 = origin=(-3.05mm, -0.17mm, -2.95mm) x=(1mm, 0mm, 0mm) y=(0mm, 1mm, 0mm) in RelativeCS66
  coordinate_system RelativeCS68 = origin=(0mm, 0mm, 2.6mm) x=(1mm, 0mm, 0mm) y=(0mm, 1mm, 0mm) in RelativeCS67
  Cell_Antenna = imported_body()
  RF_Housing_Shield [aluminum] = imported_body()
  Battery [pec] = imported_body()
  Memory_CPU, USB_VCC, USB_ID [copper] = imported_body()
  USB_Memory_3a, USB_VCC_5a [vacuum] = imported_body()
  USB_GND, USB_Memory_Secondary, USB_Memory_Primary [copper] = imported_body()
  Polyline74 [vacuum, non-model] = imported_body()
  CellAnt_GND_2, CellAnt_GND_1 [copper] = imported_body()
  Cell_Port, Polyline76, Polyline76_2 [vacuum] = imported_body()
  GPS_Substrate [GPS_LTCC2] = box(corner=(-substrate_xsize/2, -substrate_ysize/2, 0mm), size=(substrate_xsize, substrate_ysize, substrate_zsize)) in RelativeCS68
  GPS_Substrate.rotate(axis=X, angle=-90deg) in RelativeCS68
  GPS_Substrate.move(-200.99146mm, -19.955447mm, 16.644303mm) in RelativeCS68
  GPS_Patch = rectangle(corner=(-patch_xsize/2, -patch_ysize/2, substrate_zsize), x_size=patch_xsize, y_size=patch_ysize) in RelativeCS68
  Polyline79 = polyline(z=2mm, xy: (-6mm, 6mm) (-6mm, 6mm-cutoff) (-6mm+cutoff, 6mm) (-6mm, 6mm), closed, covered) in RelativeCS68
  GPS_Patch.subtract(Polyline79)
  GPS_Patch.rotate(axis=X, angle=-90deg) in RelativeCS68
  GPS_Patch.move(-200.99146mm, -19.955447mm, 16.644303mm) in RelativeCS68
  GPS_Pin [pec] = cylinder(axis=Z, base_centre=(coax_feed_xoffset, coax_feed_yoffset, 0mm), radius=coax_inner_pin_radius, height=substrate_zsize) in RelativeCS68
  GPS_Pin.rotate(axis=X, angle=-90deg) in RelativeCS68
  GPS_Pin.move(-200.99146mm, -19.955447mm, 16.644303mm) in RelativeCS68
  coordinate_system RelativeCS79 = origin=(0.84914502mm, -3.8mm, -12.083493mm) x=(1mm, 0mm, 0mm) y=(0mm, 1mm, 0mm) in RelativeCS78
  coordinate_system RelativeCS69 = origin=(2.1635866mm, -1.95mm, 16.399423mm) x=(1mm, 0mm, 0mm) y=(0mm, 1mm, 0mm) in RelativeCS79
  coordinate_system RelativeCS70 = origin=(-3.3352089mm, 6.1606132mm, -25.798337mm) x=(1mm, 0mm, 0mm) y=(0mm, 1mm, 0mm) in RelativeCS69
  coordinate_system RelativeCS71 = origin=(12.890201mm, -5.7228302mm, -7.8655765mm) x=(1mm, 0mm, 0mm) y=(0mm, 1mm, 0mm) in RelativeCS70
  coordinate_system RelativeCS72 = origin=(-17.084661mm, 2.212217mm, 1.8940437mm) x=(1mm, 0mm, 0mm) y=(0mm, 1mm, 0mm) in RelativeCS71
  coordinate_system RelativeCS73 = origin=(-14mm, -4.973268mm, 29.042368mm) x=(1mm, 0mm, 0mm) y=(0mm, 1mm, 0mm) in RelativeCS72
  coordinate_system RelativeCS74 = origin=(0mm, 0mm, 2mm) x=(1mm, 0mm, 0mm) y=(0mm, 1mm, 0mm) in RelativeCS73
  MainBoard [FR4_epoxy] = imported_body(C:\Jack\ansoft\2011_AE_meeting\model1.sat) in RelativeCS74
  Box79 = box(corner=(-187.5125mm, -18.355447mm, 31.492809mm), size=(-25.487496mm, -2.6445533mm, -0.49280908mm)) in RelativeCS68
  MainBoard.subtract(Box79)
  Box78 = box(corner=(-194.4225mm, -18.355447mm, 23.157953mm), size=(-14.75mm, -2mm, -15mm)) in RelativeCS68
  Box78.move(0.75mm, 0mm, 1mm) in RelativeCS68
  MainBoard.subtract(Box78)
  MainBoard.rotate(axis=X, angle=90deg) in RelativeCS68
  MainBoard.move(197.96961mm, 16mm, 19.955447mm) in RelativeCS68
  MainBoard.move(3.0218479mm, 0mm, 0mm) in RelativeCS68
  MainBoard.move(0mm, 0.64430292mm, 0mm) in RelativeCS68
  MainBoard.rotate(axis=X, angle=-90deg) in RelativeCS68
  MainBoard.move(-200.99146mm, -19.955447mm, 16.644303mm) in RelativeCS68
  GPS_Pin_Ground = circle(normal=Z, centre=(-0.4mm, 0.9mm, 0mm), radius=0.565mm) in RelativeCS68
  GPS_Pin_Ground.rotate(axis=X, angle=-90deg) in RelativeCS68
  GPS_Pin_Ground.move(-200.99146mm, -19.955447mm, 16.644303mm) in RelativeCS68
  Bluetooth_Antenna [copper] = polyline(z=patch_lower_elevation, xy: (-4.5mm, 15mm+Ofs_short) (0.0045meter, 15mm+Ofs_short) (0.0045meter, 15mm+Ofs_short-2mm) (-0.001meter, 15mm+Ofs_short-2mm) (-0.001meter, 15mm+Ofs_short-0.5mm) (-0.004meter, 15mm+Ofs_short-0.5mm) (-0.004meter, Ofs_short+L2+3mm) (-0.003meter, Ofs_short+L2+3mm) (-0.003meter, Ofs_short+3mm) (-0.004meter, Ofs_short+3mm) (-0.004meter, Ofs_short+0.5mm) (-0.001meter, Ofs_short+0.5mm) (-0.001meter, Ofs_short+3mm) (-3MM+W2, Ofs_short+3mm) (-3mm+W2, 15mm+Ofs_short-W2-2mm) (0.0045meter, 15mm+Ofs_short-W2-2mm) (0.0045meter, Ofs_short+W1+1mm) (W1, Ofs_short+W1+1mm) (W1, Ofs_short+L1+2mm) (0meter, Ofs_short+L1+2mm) (0meter, Ofs_short+1mm) (0.0045meter, Ofs_short+1mm) (0.0045meter, Ofs_short) (-0.0045meter, Ofs_short) (-4.5mm, 15mm+Ofs_short), closed, covered) in RelativeCS68
  inner_pin_top1 = circle(normal=Z, centre=(0mm, 0, GND_lower_elevation), radius=0.25mm) in RelativeCS68
  inner_pin_top1.move(4.5mm-Ofs_fedX, Ofs_short+2mm+Ofs_fedY, 0mm) in RelativeCS68
  via_9_hole_section1 = circle(normal=Z, centre=(0mm, 2.1684043e-16mm, patch_lower_elevation), radius=0.25mm) in RelativeCS68
  via_9_hole_section1.move(4.5mm-Ofs_fedX, Ofs_short+2mm+Ofs_fedY, 0mm) in RelativeCS68
  inner_pin_top1.connect(via_9_hole_section1)
  via_9_hole_2 = inner_pin_top1.copy()
  Bluetooth_Antenna.subtract(via_9_hole_2)
  inner_pin_top1.delete()
  Bluetooth_Antenna.rotate(axis=X, angle=-90deg) in RelativeCS68
  Bluetooth_Antenna.move(-129.4985mm, -19.955447mm, 17.200441mm) in RelativeCS68
  Bluetooth_Antenna.rotate(axis=Y, angle=90deg) in RelativeCS68
  Bluetooth_Antenna.move(-126.69894mm, 3.5527137e-15mm, -132.29806mm) in RelativeCS68
  Bluetooth_Antenna.move(0mm, 0mm, -13.17974mm) in RelativeCS68
  Bluetooth_Antenna.rotate(axis=Y, angle=90deg) in RelativeCS68
  Bluetooth_Antenna.move(-176.91649mm, 0mm, -137.19703mm) in RelativeCS68
  Bluetooth_Antenna.move(-9.2018664mm, 0mm, 0mm) in RelativeCS68
  Bluetooth_Antenna.move(0mm, 0mm, -4.3444516mm) in RelativeCS68
  Bluetooth_Antenna.move(0mm, -3.5mm, 0mm) in RelativeCS68
  Bluetooth_Antenna.move(0mm, -0.77056304mm, 0mm) in RelativeCS68
  Bluetooth_Shorting_Pin = rectangle(corner=(-206.59766mm, -17.22601mm, -22.042978mm), x_size=2.50744mm, y_size=-2.729437mm) in RelativeCS68
  Bluetooth_Pin [pec] = cylinder(axis=Y, base_centre=(-204.84766mm, -19.955447mm, -14.042978mm), radius=0.25mm, height=2.729437mm) in RelativeCS68
  Bluetooth_Pin_Ground = circle(normal=Y, centre=(-204.84766mm, -19.955447mm, -14.042978mm), radius=0.60207973mm) in RelativeCS68
  Bluetooth_Substrate [foam] = box(corner=(-212.89579mm, -19.955447mm, -27.698526mm), size=(14.798134mm, 2.729437mm, 20.155548mm)) in RelativeCS68
  Bluetooth_Substrate.move(2.50744mm, 0mm, 0mm) in RelativeCS68
  Bluetooth_Substrate.move(0mm, 0mm, 3.2580883mm) in RelativeCS68
  coordinate_system RelativeCS77 = origin=(-112.60058mm, -5.4910893mm, 0.52920162mm) x=(1mm, 0mm, 0mm) y=(0mm, 1mm, 0mm) in RelativeCS68
  coordinate_system RelativeCS78 = origin=(19.691433mm, 1.1mm, -2.4457084mm) x=(1mm, 0mm, 0mm) y=(0mm, 1mm, 0mm) in RelativeCS77
  [GPS_Substrate, GPS_Patch, GPS_Pin, MainBoard, GPS_Pin_Ground, Bluetooth_Antenna, Bluetooth_Shorting_Pin, Bluetooth_Pin, Bluetooth_Pin_Ground, Bluetooth_Substrate].move(202.47608mm, 15.898458mm, -3.5721413mm) in RelativeCS68
  Box80 = box(corner=(-7.9122665mm, -1.3275518mm, -7.857031mm), size=(14.798134mm, -2.729437mm, -20.155548mm)) in RelativeCS68
  MainBoard.subtract(Box80)
  USB_GND_GNDBlock = rectangle(corner=(11.883579mm, -4.1036875mm, -27.489334mm), z_size=-1.0828077mm, x_size=0.25mm) in RelativeCS68
  USB_GNDBlock [pec] = box(corner=(8.6835786mm, -4.0569888mm, -28.572141mm), size=(4.5mm, -0.12572647mm, -0.31427712mm)) in RelativeCS68
  USB_VCC_5b = rectangle(corner=(11.883579mm, -4.1036875mm, -27.489334mm), z_size=-1.0828077mm, x_size=0.25mm) in RelativeCS68
  USB_GND_GNDBlock.move(-0.65mm, 0mm, 0mm) in RelativeCS68
  USB_Memory_Secondary_GNDBlock = rectangle(corner=(11.883579mm, -4.1036875mm, -27.489334mm), z_size=-1.0828077mm, x_size=0.25mm) in RelativeCS68
  [USB_Memory_Secondary_GNDBlock, USB_GND_GNDBlock].move(-0.65mm, 0mm, 0mm) in RelativeCS68
  USB_Memory_3b = rectangle(corner=(11.883579mm, -4.1036875mm, -27.489334mm), z_size=-1.0828077mm, x_size=0.25mm) in RelativeCS68
  USB_Memory_3b.move(-0.65mm, 0mm, 0mm) in RelativeCS68
  [USB_Memory_3b, USB_GND_GNDBlock].move(-0.65mm, 0mm, 0mm) in RelativeCS68
  USB_ID_GNDBlock = rectangle(corner=(11.883579mm, -4.1036875mm, -27.489334mm), z_size=-1.0828077mm, x_size=0.25mm) in RelativeCS68
  USB_ID_GNDBlock.move(-0.65mm, 0mm, 0mm) in RelativeCS68
  USB_ID_GNDBlock.move(-0.65mm, 0mm, 0mm) in RelativeCS68
  [USB_ID_GNDBlock, USB_GND_GNDBlock].move(-0.65mm, 0mm, 0mm) in RelativeCS68
  USB_Memory_Secondary_Ground [vacuum] = imported_body() in RelativeCS68
  USB_Memory_Secondary_Ground.move(202.47608mm, 15.898458mm, -4.5721413mm) in RelativeCS68
  Mem_To_CPUa = rectangle(corner=(45.276083mm, -2.4569888mm, 15.927859mm), x_size=-0.6mm, y_size=-1.6mm) in RelativeCS68
  Mem_To_CPUb = rectangle(corner=(20.476083mm, -2.3869888mm, 6.4278587mm), y_size=-1.67mm, z_size=0.6mm) in RelativeCS68
  Box81 = box(corner=(-5.9464134mm, -2.4569888mm, 5.5858116mm), size=(12.832281mm, -0.8mm, -13.442843mm)) in RelativeCS68
  MainBoard.subtract(Box81)
  Region [vacuum] = region(absolute_offset=3in on all sides) in RelativeCS68
  Ground = imported_body()
  list Objectlist1 = Cell_Antenna, Ground, GPS_Substrate, Bluetooth_Substrate
boundaries and excitations:
  Cell_Antenna: Finite Conductivity Objects=Cell_Antenna Conductivity=58000000 Permeability=1
  Bluetooth_Antenna: Finite Conductivity Objects=Bluetooth_Antenna Conductivity=58000000 Permeability=1
  Ground: Finite Conductivity Objects=Ground Conductivity=58000000 Permeability=1
  GPS_Patch: Finite Conductivity Objects=GPS_Patch Conductivity=58000000 Permeability=1
  Bluetooth_Shorting_Pin: Finite Conductivity Objects=Bluetooth_Shorting_Pin Conductivity=58000000 Permeability=1
  USB_GND_GNDBlock: Perfect E Objects=USB_GND_GNDBlock
  USB_ID_GNDBlock: Perfect E Objects=USB_ID_GNDBlock
  USB_Memory_Secondary_GroundGNDBlock: Perfect E Objects=[USB_Memory_Secondary_Ground, USB_Memory_Secondary_GNDBlock]
  RF_Housing_Shield: Perfect E Objects=RF_Housing_Shield
  RadiationBoundary: Radiation Objects=Region
  Bluetooth_Port: Terminal port=Bluetooth Faces=Bluetooth_Pin.face(at (-204.848, -19.9554, -14.043)) TerminalResistance=50ohm
  Cell_Port: Terminal port=Cell Edges=CellAnt_GND_1.edge(at (-211.602, -19.9554, -6.16675)) TerminalResistance=50ohm
  GPS_Port: Terminal port=GPS Faces=GPS_Pin.face(at (-201.391, -19.9554, 15.7443)) TerminalResistance=50ohm
  Mem_To_CPUa: Terminal port=Mem_To_CPUa_1 Edges=Memory_CPU.edge(at (-157.5, -18.3554, 19.5)) TerminalResistance=50ohm
  Mem_To_CPUb: Terminal port=Mem_To_CPUb_1 Edges=Memory_CPU.edge(at (-182, -18.2854, 10.3)) TerminalResistance=50ohm
  USB_Memory_3a: Terminal port=USB_Memory_3a_1 Edges=USB_Memory_Primary.edge(at (-186.5, -18.3554, 16.3)) TerminalResistance=50ohm
  USB_Memory_3b: Terminal port=USB_Memory_3b_1 Edges=USB_Memory_Primary.edge(at (-191.768, -20.0021, -23.9172)) TerminalResistance=50ohm
  USB_VCC_5a: Terminal port=USB_VCC_5a_1 Edges=USB_VCC.edge(at (-166, -18.3554, -1)) TerminalResistance=50ohm
  USB_VCC_5b: Terminal port=USB_VCC_5b_1 Edges=USB_VCC.edge(at (-190.468, -20.0021, -23.9172)) TerminalResistance=50ohm
  USB_Memory_3a_1: Lumped Port Objects=USB_Memory_3a LumpedPortType=Terminal Impedance=50ohm
  USB_VCC_5a_1: Lumped Port Objects=USB_VCC_5a LumpedPortType=Terminal Impedance=50ohm
  GPS: Lumped Port Objects=GPS_Pin_Ground LumpedPortType=Terminal Impedance=50ohm
  Bluetooth: Lumped Port Objects=Bluetooth_Pin_Ground LumpedPortType=Terminal Impedance=50ohm
  USB_VCC_5b_1: Lumped Port Objects=USB_VCC_5b LumpedPortType=Terminal Impedance=50ohm
  Cell: Lumped Port Objects=Cell_Port LumpedPortType=Terminal Impedance=50ohm
  USB_Memory_3b_1: Lumped Port Objects=USB_Memory_3b LumpedPortType=Terminal Impedance=50ohm
  Mem_To_CPUa_1: Lumped Port Objects=Mem_To_CPUa LumpedPortType=Terminal Impedance=50ohm
  Mem_To_CPUb_1: Lumped Port Objects=Mem_To_CPUb LumpedPortType=Terminal Impedance=50ohm
  reference conductors: Ground, USB_GNDBlock
mesh:
  SurfApprox: SurfApproxBased Objects=Cell_Antenna CurvedSurfaceApproxChoice=ManualSettings NormalDev=10deg
  SurfPriority1: SurfaceRepPriority Objects=Cell_Antenna SurfaceRepPriority=0
  initial mesh: MeshMethod=AnsoftClassic
setups:
  Setup: HfssDriven Frequency=3GHz MaxDeltaS=0.01 MaximumPasses=40 MinimumPasses=1 MinimumConvergedPasses=2 PercentRefinement=10 BasisOrder=-1 PortAccuracy=2 DrivenSolverType="Direct Solver" IESolverType=ACA
    sweep Sweep: 0GHz to 3GHz step 0.01GHz; Type=Interpolating InterpTolerance=0.5 InterpMaxSolns=250 MinSolvedFreq=0.01GHz PassivityErrorTolerance=0.0001
source amplitudes:
  USB_Memory_3a_1:1: 1V 0deg
  USB_VCC_5a_1:1, GPS:1, Bluetooth:1, USB_VCC_5b_1:1, Cell:1, USB_Memory_3b_1:1, Mem_To_CPUa_1:1, Mem_To_CPUb_1:1: 0V 0deg
reports:
  S11_CellAntenna: dB(S(Cell_Port,Cell_Port)) vs Freq on Setup : Sweep
  S11_GPSAntenna: dB(S(GPS_Port,GPS_Port)) vs Freq on Setup : Sweep
  S11_BluetoothAntenna: dB(S(Bluetooth_Port,Bluetooth_Port)) vs Freq on Setup : Sweep
  Isolation: dB(S(USB_Memory_3a,GPS_Port)), dB(S(USB_Memory_3a,Bluetooth_Port)), dB(S(USB_Memory_3a,Cell_Port)), dB(S(USB_VCC_5a,GPS_Port)), dB(S(USB_VCC_5a,Bluetooth_Port)), dB(S(USB_VCC_5a,Cell_Port)), dB(S(GPS_Port,Bluetooth_Port)), dB(S(GPS_Port,Cell_Port)), dB(S(Bluetooth_Port,GPS_Port)), dB(S(Bluetooth_Port,Cell_Port)), dB(S(USB_VCC_5b,GPS_Port)), dB(S(USB_VCC_5b,Bluetooth_Port)), dB(S(USB_VCC_5b,Cell_Port)), dB(S(Cell_Port,GPS_Port)), dB(S(Cell_Port,Bluetooth_Port)), dB(S(USB_Memory_3b,GPS_Port)), dB(S(USB_Memory_3b,Bluetooth_Port)), dB(S(USB_Memory_3b,Cell_Port)), dB(S(Mem_To_CPUa,GPS_Port)), dB(S(Mem_To_CPUa,Bluetooth_Port)), dB(S(Mem_To_CPUa,Cell_Port)), dB(S(Mem_To_CPUb,GPS_Port)), dB(S(Mem_To_CPUb,Bluetooth_Port)), dB(S(Mem_To_CPUb,Cell_Port)) vs Freq on Setup : Sweep

design EMIT Design1 (EMIT Design)
components:
  Antenna_31 = Antenna(Name=WiFi)
  Antenna_32 = Antenna(Name=Cellular)
  Antenna_33 = Antenna(Name=GPS)
  Emitter_34 = Emitter(Name=USB_Memory_3a)
  GPS Receiver_36 = GPS Receiver(Name="GPS Receiver")
  WiFi - 802.11-2012_38 = WiFi - 802.11-2012(Name="WiFi - 802.11-2012")
  GSM Mobile Station_40 = GSM Mobile Station(Name="GSM Mobile Station")
  TR Switch_42 = TR Switch(Name="TR Switch")
  TR Switch_44 = TR Switch(Name="TR Switch 2")
  Amplifier_46 = Amplifier(Name=Amplifier)
nets:
  net_1: Antenna_33.0, GPS Receiver_36.0
  net_2: Antenna_31.0, WiFi - 802.11-2012_38.0
  net_3: TR Switch_42.2, Antenna_32.0
  net_4: GSM Mobile Station_40.0, TR Switch_44.2
  net_5: Amplifier_46.0, TR Switch_44.1
  net_6: Amplifier_46.1, TR Switch_42.1
  net_7: TR Switch_42.0, TR Switch_44.0
