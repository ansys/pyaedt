# Ansys Electronics Desktop project, version 2023.2

design EMIT Design1 (EMIT Design)
components:
  Bluetooth Low Energy (LE)_1 = Bluetooth Low Energy (LE)(Name=Bluetooth)
  Antenna_2 = Antenna(Name=Antenna)
  GPS Receiver_3 = GPS Receiver(Name=GPS)
  Antenna_4 = Antenna(Name="Antenna 2")
  WiFi - 802.11-2012_5 = WiFi - 802.11-2012(Name=WiFi)
  Antenna_6 = Antenna(Name="Antenna 3")
nets:
  net_1: Antenna_2.0, Bluetooth Low Energy (LE)_1.0
  net_2: GPS Receiver_3.0, Antenna_4.0
  net_3: WiFi - 802.11-2012_5.0, Antenna_6.0
