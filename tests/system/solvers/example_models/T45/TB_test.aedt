# Ansys Electronics Desktop project, version 2024.1

design Transistor_Validation (Twin Builder)
variables:
  COUT = 3e-09
components:
  FML_INIT1 = FML_INIT(EQU0="Vg_on:= 15" EQU1="Vg_off:= -15" EQU2="Rgate_on:= 4.3" EQU3="Rgate_off:= 25" EQU4="Cge_ext:= 68n" EQU5="VACT:= 3600" EQU6="IACT:= 600" EQU7="TACT:= 125" EQU8="L_extern:= 280e-9" EQU10="FSync:=1/Period" EQU9="Period:= 400u" EQU11="CLoad:= 1p" EQU12="Ampl:=(Vg_on - Vg_off)/2" EQU13="Offs:=(Vg_on + Vg_off)/2" EQU14="Hmax:= Period/200" EQU15="Hmin:= 10n" EQU16="Cycles:= 5" EQU17="Tend:= Cycles*Period")
  Measurement = FML_INIT(EQU0="HON:= 15u" EQU1="HOFF:= 15u")
  L_supply = L(I0=0A L=L_extern)
  StartUp = FML(EQU0="if(Time<Period/100) { / // start up voltage and load current / IQ:= Time/Period *100*IACT; / VQ:= Time/Period *100*VACT; / } / else { / IQ:= IACT; / VQ:=VACT; / };")
  R1 = R(R=Rgate_on)
  FWD2 = D(Type=DEXP ISAT=0.001A VT=0.01V)
  FWD3 = D(Type=DEXP ISAT=0.001A VT=0.01V)
  R2 = R(R=Rgate_off)
  C_ge = C(UseInitialConditions=true V0=0V C=Cge_ext I=0 V=0)
  Ecc = E(EMF=VQ PERIO=0)
  L_supply1 = L(I0=0A L=L_extern)
  L_supply2 = L(I0=0A L=L_extern)
nets:
  0: L_supply.1, C_ge.1, Ecc.0, L_supply2.0
  inH: R2.0, FWD2.0, L_supply1.1
  net_13: L_supply2.1, L_supply1.0
  net_15: L_supply.0, Ecc.1
  net_17: R1.0, FWD2.1
  net_22: R2.1, FWD3.1
  net_9: R1.1, C_ge.0, FWD3.0
setups:
  TR: TransientData(100ns, 1ns, 10ns, false, "")
  Options: ModifiedOptions{ts_intmethod=0 gen_stepwidth=1 ts_advstepmode=0}
optimetrics:
  trend COUT: Parametric SaveSolutions Sim._Setups=[TR]
    sweep COUT: DEC 1e-011 1e-007 5
    table edits: del(6.30957344480193e-008) del(2.51188643150958e-008) del(1.58489319246111e-008) del(6.30957344480193e-009) del(2.51188643150958e-009) del(1.58489319246111e-009) del(6.30957344480193e-010) del(2.51188643150958e-010) del(1.58489319246111e-010) del(6.30957344480193e-011) del(2.51188643150958e-011) del(1.58489319246111e-011)
    calculate mean(AM_IC.I) on TR : TR at Time all
reports:
  on edge: AM_IC.I, VM_VCE.V, VM_VGE.V, AM_fwd.I vs Time on TR : TR; markers MX1 at x=0.0015094048, MX2 at x=0.001499, MX3 at x=0.0015003433, MX4 at x=0.0015057715
  off edge: AM_IC.I, VM_VCE.V, VM_VGE.V vs Time on TR : TR
  time goals: Sampling.t_OFF, Sampling.t_ON, Interpolation.t_OFF, Interpolation.t_ON vs Time on TR : TR; markers T_ON at 0.64708891ms, T_OFF at 649088.91ns
  energy goals: Interpolation.E_OFF, Interpolation.E_ON, Sampling.E_OFF, Sampling.E_ON vs Time on TR : TR
  power loss: Interpolation.P2, Interpolation.P2_MEAN, Sampling.P2, Sampling.P2_MEAN vs Time on TR : TR
  delay_times: Interpolation.t_I20H, Interpolation.t_I20L, Interpolation.t_I21H, Interpolation.t_I21L, Sampling.t_I20H, Sampling.t_I20L, Sampling.t_I21H, Sampling.t_I21L vs Time on TR : TR
  special values: VM_VGE.V, Interpolation.F2_TOT, Interpolation.Q1_TOT, Interpolation.Q2_TOT vs Time on TR : TR
