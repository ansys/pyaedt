# Ansys Electronics Desktop project, version 2023.1
materials:
  air: permittivity=1.0006 permeability=1.0000004
  copper: permeability=0.999991 conductivity=58000000
  FR4_epoxy: permittivity=4.4 dielectric_loss_tangent=0.02
  pec: conductivity=1e+30
  vacuum: permittivity=1

design EMDesign1 (HFSS 3D Layout)
ports:
  Port1, Port2: Properties{Reference=gnd:rect_3 Impedance=50ohm Magnitude=1V Phase=0deg Renormalize_Impedence="50ohm + 0i ohm" Renormalize Deembed_Distance=0mm Deembed Type="Single Strip Gap Source" HFSS_Type=Gap Orientation=Vertical Layer_Alignment=Upper Horizontal_Extent_Factor=5 Vertical_Extent_Factor=3 PEC_Launch_Width=0.1mm} Type=EdgePort
setups:
  Setup1: SolveSetupType=HFSS PercentRefinementPerPass=30 MinNumberOfPasses=1 MinNumberOfConvergedPasses=1 Frequency=10GHz MeshSizeFactor=1.5 ViaNumSides=6 ViaMaterial=copper Style25DVia=Mesh
    sweep Sweep1: LIN 0GHz 2GHz 0.1GHz; SAbsError=0.005 ZoPercentError=1 PassivityTolerance=0.0001 MaxSolutions=250 InterpUseSMatrix InterpUsePortImpedance InterpUseFullBasis MinSolvedFreq=0.01GHz AutoSMatOnlySolve MinFreqSMatrixOnlySolve=1MHz MagMinThreshold=0.01 FreqSweepType=kInterpolating
