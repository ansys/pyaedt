# Ansys Electronics Desktop project, version 2024.1
materials:
  vacuum: permittivity=1

design push (HFSS, HFSS Terminal Network, model units mm)
geometry:
  Box1 [vacuum] = box(corner=(-0.4mm, 0.2mm, 0mm), size=(0.8mm, -0.4mm, 0.4mm))
boundaries and excitations:
  1: Wave Port Faces=Box1.face(+z) WavePortType=Modal NumModes=1 Modes{Mode1{CharImp=Zpi}}
source amplitudes:
  1:1: 1V 0deg
