# Ansys Electronics Desktop project, version 2027.1

design EMIT Design1 (EMIT Design)
components:
  New Radio_1 = New Radio(Name=Radio)
  Antenna_2 = Antenna(Name=Bowtie)
  New Radio_6 = New Radio(Name="Radio 1")
  Antenna_7 = Antenna(Name=Iso)
nets:
  net_1: New Radio_1.0, Antenna_2.0
  net_2: New Radio_6.0, Antenna_7.0
