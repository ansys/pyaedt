# Ansys Electronics Desktop project, version 2025.2

design Nto1 (EMIT Design)
components:
  Antenna_2 = Antenna(Name=Antenna)
  Antenna_4 = Antenna(Name="Antenna 2")
  Antenna_6 = Antenna(Name="Antenna 3")
  Antenna_8 = Antenna(Name="Antenna 4")
  New Radio_10 = New Radio(Name="Tx1 - TxRadio1")
  New Radio_12 = New Radio(Name="Tx2 - TxRadio2")
  New Radio_14 = New Radio(Name="Tx3 - TxRadio3")
  New Radio_16 = New Radio(Name="Rx - RxRadio")
nets:
  net_1: Antenna_2.0, New Radio_10.0
  net_2: Antenna_4.0, New Radio_12.0
  net_3: Antenna_8.0, New Radio_14.0
  net_4: Antenna_6.0, New Radio_16.0
