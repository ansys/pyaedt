# Ansys Electronics Desktop project, version 2025.2

design NonNumericResults (EMIT Design)
components:
  Antenna_2 = Antenna(Name=Antenna)
  Antenna_4 = Antenna(Name="Antenna 2")
  Antenna_6 = Antenna(Name="Antenna 3")
  Antenna_8 = Antenna(Name="Antenna 4")
  Antenna_10 = Antenna(Name="Antenna 5")
  Antenna_12 = Antenna(Name="Antenna 6")
  Antenna_14 = Antenna(Name="Antenna 7")
  New Radio_16 = New Radio(Name="High Power Tx - High Power Tx")
  New Radio_18 = New Radio(Name="Low Power Tx - Low Power Tx")
  New Radio_20 = New Radio(Name="Low Susc Rx - Low Susc Rx")
  New Radio_22 = New Radio(Name="High Susc Rx - High Susc Rx")
  New Radio_24 = New Radio(Name="Amp Sat - Amp Sat")
  Amplifier_26 = Amplifier(Name=Amplifier)
  New Radio_28 = New Radio(Name="Self Interaction - Self Interaction")
  Circulator_30 = Circulator(Name=Circulator)
  Circulator_32 = Circulator(Name="Circulator 2")
  New Radio_34 = New Radio(Name="RF System - Null")
nets:
  net_1: Circulator_30.2, Circulator_32.1
  net_10: New Radio_28.0, Circulator_30.0
  net_11: New Radio_34.0, Antenna_14.0
  net_2: Circulator_30.1, Circulator_32.2
  net_3: Antenna_2.0, New Radio_16.0
  net_4: Antenna_4.0, New Radio_18.0
  net_5: New Radio_20.0, Antenna_6.0
  net_6: Antenna_8.0, New Radio_22.0
  net_7: New Radio_24.0, Amplifier_26.0
  net_8: Antenna_10.0, Amplifier_26.1
  net_9: Circulator_32.0, Antenna_12.0
