# Ansys Electronics Desktop project, version 2027.1

design EMIT Design1 (EMIT Design)
components:
  New Radio_1 = New Radio(Name=Tx_OneBand)
  New Radio_2 = New Radio(Name=Tx_MultiBands)
  New Radio_3 = New Radio(Name=Rx_OneBand)
  Antenna_4 = Antenna(Name=Antenna)
  Antenna_5 = Antenna(Name="Antenna 2")
  Antenna_6 = Antenna(Name="Antenna 3")
  New Radio_10 = New Radio(Name=Rx_MultiBands)
  Antenna_11 = Antenna(Name="Antenna 1")
  New Radio_17 = New Radio(Name=Tx3)
  Antenna_20 = Antenna(Name="Antenna 5")
nets:
  net_1: Antenna_4.0, New Radio_2.0
  net_2: New Radio_1.0, Antenna_5.0
  net_3: Antenna_6.0, New Radio_3.0
  net_4: Antenna_11.0, New Radio_10.0
  net_6: New Radio_17.0, Antenna_20.0
