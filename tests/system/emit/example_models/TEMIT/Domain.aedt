# Ansys Electronics Desktop project, version 2027.1

design EMIT Design1 (EMIT Design)
components:
  New Radio_1 = New Radio(Name=Radio)
  New Radio_2 = New Radio(Name="Radio 2")
  New Radio_3 = New Radio(Name="Radio 3")
  Antenna_4 = Antenna(Name="Antenna 3")
  Antenna_6 = Antenna(Name="Antenna 2")
  New Radio_7 = New Radio(Name="Radio 4")  # Inactive_Open
  Antenna_8 = Antenna(Name="Antenna 4")
  New Radio_9 = New Radio(Name="Radio 5")
  Antenna_10 = Antenna(Name="Antenna 5")
nets:
  net_1: New Radio_3.0, Antenna_4.0
  net_3: Antenna_6.0, New Radio_2.0
  net_4: New Radio_7.0, Antenna_8.0
  net_5: New Radio_9.0, Antenna_10.0
