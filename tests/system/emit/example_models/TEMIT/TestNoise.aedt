# Ansys Electronics Desktop project, version 2027.1

design EMIT Design1 (EMIT Design)
components:
  New Radio_1 = New Radio(Name=Radio)
  New Radio_2 = New Radio(Name="Radio 2")
  Antenna_3 = Antenna(Name=Antenna)
  Antenna_4 = Antenna(Name="Antenna 2")
  Low Pass_5 = Low Pass(Name=Filter)
nets:
  net_1: New Radio_2.0, Antenna_3.0
  net_4: New Radio_1.0, Low Pass_5.0
  net_5: Low Pass_5.1, Antenna_4.0
