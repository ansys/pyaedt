# Ansys Electronics Desktop project, version 2025.2

design Availability (EMIT Design)
components:
  Antenna_2 = Antenna(Name=Antenna)
  Antenna_4 = Antenna(Name="Antenna 2")
  Antenna_6 = Antenna(Name="Antenna 3")
  New Radio_8 = New Radio(Name="RF System - SelfInteracting")
  Divider_10 = Divider(Name="Power Divider")
  Divider_12 = Divider(Name="Power Divider 2")
  Low Pass_14 = Low Pass(Name=Filter)
  New Radio_16 = New Radio(Name="RF System 2 - OneChannel")
  New Radio_18 = New Radio(Name="RF System 3 - Radio")
nets:
  net_1: Divider_12.1, Divider_10.1
  net_2: Divider_12.2, Divider_10.2
  net_3: Low Pass_14.1, Divider_10.0
  net_4: Divider_12.0, Antenna_2.0
  net_5: Low Pass_14.0, New Radio_8.0
  net_6: New Radio_16.0, Antenna_4.0
  net_7: New Radio_18.0, Antenna_6.0
