# Ansys Electronics Desktop project, version 2023.1
project datasets:
  $ds1: (22, 1) (200, 0.6)
materials:
  AIR: permittivity=1 permeability=1
  Al-Extruded
  BOTTOM_FILL: permittivity=4.5 permeability=1
  COPPER: thermal_modifier{Property=conductivity free_form_value=pwl($ds1,Temp)} conductivity=59590000
  COPPER_1: conductivity=59590000
  FR-4: permittivity=3.86 permeability=1 dielectric_loss_tangent=0.024
  FR-4_1: permittivity=4.5 permeability=1 dielectric_loss_tangent=0.035
  FR-4_2: permittivity=4.34 permeability=1 dielectric_loss_tangent=0.018
  FR-4_3: permittivity=3.86 permeability=1 dielectric_loss_tangent=0.024
  FR4_epoxy: permittivity=4.4 dielectric_loss_tangent=0.02
  GND_FILL: permittivity=4.5 permeability=1 dielectric_loss_tangent=0.035
  LYR_1_FILL: permittivity=4.5 permeability=1 dielectric_loss_tangent=0.035
  LYR_2_FILL: permittivity=4.5 permeability=1 dielectric_loss_tangent=0.035
  pec: conductivity=1e+30
  PWR_FILL: permittivity=4.5 permeability=1 dielectric_loss_tangent=0.035
  solder: conductivity=7000000
  Teflon (tm): permittivity=2.1 dielectric_loss_tangent=0.001
  TOP_FILL: permittivity=4.5 permeability=1
  vacuum: permittivity=1
surface materials:
  Steel-oxidised-surface

design Galileo_G87173_205_cutout3 (HFSS 3D Layout)
nets:
  USBH2_DN_CH: port L3M1.3.USBH2_DN_CH, port J3B2.2.USBH2_DN_CH
  USBH2_DP_CH: port J3B2.3.USBH2_DP_CH, port L3M1.2.USBH2_DP_CH
ports:
  J3B2.2.USBH2_DN_CH: Properties{Reference=GND:GND:poly_2828 Impedance=50ohm Magnitude=0 Phase=0deg Renormalize_Impedence="50ohm + 0i ohm" Renormalize Deembed_Distance=0mm Deembed Type="Pad Port Gap Source" HFSS_Type=Gap Orientation=Vertical Layer_Alignment=Upper Horizontal_Extent_Factor=5 Vertical_Extent_Factor=3 PEC_Launch_Width=0mm Terminated Reference_Net=GND} Type="Pad Port" Pin=J3B2.2.USBH2_DN_CH Material=copper ViaMesh=Wirebond Sides=3
  J3B2.3.USBH2_DP_CH: Properties{Reference=GND:GND:poly_2828 Impedance=50ohm Magnitude=0 Phase=0deg Renormalize_Impedence="50ohm + 0i ohm" Renormalize Deembed_Distance=0mm Deembed Type="Pad Port Gap Source" HFSS_Type=Gap Orientation=Vertical Layer_Alignment=Upper Horizontal_Extent_Factor=5 Vertical_Extent_Factor=3 PEC_Launch_Width=0mm Terminated Reference_Net=GND} Type="Pad Port" Pin=J3B2.3.USBH2_DP_CH Material=copper ViaMesh=Wirebond Sides=3
  L3M1.2.USBH2_DP_CH: Properties{Reference=GND:GND:poly_2828 Impedance=50ohm Magnitude=50 Phase=0deg Renormalize_Impedence="50ohm + 0i ohm" Renormalize Deembed_Distance=0mm Deembed Type="Pad Port Gap Source" HFSS_Type=Gap Orientation=Vertical Layer_Alignment=Lower Horizontal_Extent_Factor=5 Vertical_Extent_Factor=3 PEC_Launch_Width=0mm Reference_Net=GND} Type="Pad Port" Pin=L3M1.2.USBH2_DP_CH Material=copper ViaMesh=Wirebond Sides=3
  L3M1.3.USBH2_DN_CH: Properties{Reference=GND:GND:poly_2828 Impedance=50ohm Magnitude=50 Phase=0deg Renormalize_Impedence="50ohm + 0i ohm" Renormalize Deembed_Distance=0mm Deembed Type="Pad Port Gap Source" HFSS_Type=Gap Orientation=Vertical Layer_Alignment=Lower Horizontal_Extent_Factor=5 Vertical_Extent_Factor=3 PEC_Launch_Width=0mm Reference_Net=GND} Type="Pad Port" Pin=L3M1.3.USBH2_DN_CH Material=copper ViaMesh=Wirebond Sides=3
setups:
  HFSS Setup 1: SolveSetupType=HFSS PercentRefinementPerPass=30 MinNumberOfPasses=1 MinNumberOfConvergedPasses=1 Frequency=10GHz MeshSizeFactor=1.5 ViaNumSides=6 ViaMaterial=copper Style25DVia=Mesh
    sweep Sweep 1: LIN 0GHz 20GHz 0.05GHz; SAbsError=0.005 ZoPercentError=1 PassivityTolerance=0.0001 MaxSolutions=250 InterpUseSMatrix InterpUsePortImpedance InterpUseFullBasis MinSolvedFreq=0.01GHz AutoSMatOnlySolve MinFreqSMatrixOnlySolve=1MHz MagMinThreshold=0.01 FreqSweepType=kInterpolating

design Circuit2 (Circuit)
options: SParamCircuitDef IntegrationMethod=FFT
components:
  U75 = Galileo_G87173_205_cutout3()
  S76 = uUSB3()
nets:
  net_1: S76.0, U75.1
  net_2: S76.1, U75.3
