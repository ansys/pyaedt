# Ansys Electronics Desktop project, version 2021.2
materials:
  air: permittivity=1.0006
  copper: permeability=1 conductivity=59590000
  FR4_epoxy: permittivity=4.4 dielectric_loss_tangent=0.02
  solder: permeability=1 conductivity=7000000
  SolderMask: permittivity=3.1 dielectric_loss_tangent=0.035
  pec: conductivity=1e+30

design FlipChip_TopBot (HFSS 3D Layout)
nets:
  FCHIP_A1: port FCHIP_A1_FCHIP_A1, port FCHIP_A1_BGA_C3
  FCHIP_A12: port FCHIP_A12_FCHIP_A12, port FCHIP_A12_BGA_C7
  FCHIP_A13: port FCHIP_A13_FCHIP_A13, port FCHIP_A13_BGA_B7
  FCHIP_A16: port FCHIP_A16_FCHIP_A16, port FCHIP_A16_BGA_A10
  FCHIP_A17: port FCHIP_A17_FCHIP_A17, port FCHIP_A17_BGA_B10
  FCHIP_A18: port FCHIP_A18_FCHIP_A18, port FCHIP_A18_BGA_C10
  FCHIP_A2: port FCHIP_A2_FCHIP_A2, port FCHIP_A2_BGA_B3
  FCHIP_A3: port FCHIP_A3_FCHIP_A3, port FCHIP_A3_BGA_A3
  FCHIP_A6: port FCHIP_A6_FCHIP_A6, port FCHIP_A6_BGA_B6
  FCHIP_A7: port FCHIP_A7_FCHIP_A7, port FCHIP_A7_BGA_C6
  FCHIP_B13: port FCHIP_B13_FCHIP_B13, port FCHIP_B13_BGA_B8
  FCHIP_B14: port FCHIP_B14_FCHIP_B14, port FCHIP_B14_BGA_A9
  FCHIP_B15: port FCHIP_B15_FCHIP_B15, port FCHIP_B15_BGA_B9
  FCHIP_B16: port FCHIP_B16_FCHIP_B16, port FCHIP_B16_BGA_C9
  FCHIP_B3: port FCHIP_B3_FCHIP_B3, port FCHIP_B3_BGA_C4
  FCHIP_B4: port FCHIP_B4_FCHIP_B4, port FCHIP_B4_BGA_B4
  FCHIP_B5: port FCHIP_B5_FCHIP_B5, port FCHIP_B5_BGA_A4
  FCHIP_B6: port FCHIP_B6_FCHIP_B6, port FCHIP_B6_BGA_B5
  FCHIP_C17: port FCHIP_C17_FCHIP_C17, port FCHIP_C17_BGA_D11
  FCHIP_C2: port FCHIP_C2_FCHIP_C2, port FCHIP_C2_BGA_D2
  FCHIP_D17: port FCHIP_D17_FCHIP_D17
  FCHIP_D2: port FCHIP_D2_FCHIP_D2
  FCHIP_E17: port FCHIP_E17_FCHIP_E17
  FCHIP_E2: port FCHIP_E2_FCHIP_E2
  FCHIP_F17: port FCHIP_F17_FCHIP_F17, port FCHIP_F17_BGA_E11
  FCHIP_F2: port FCHIP_F2_FCHIP_F2, port FCHIP_F2_BGA_E2
  FCHIP_G17: port FCHIP_G17_FCHIP_G17
  FCHIP_G2: port FCHIP_G2_FCHIP_G2
  FCHIP_H17: port FCHIP_H17_FCHIP_H17, port FCHIP_H17_BGA_F10
  FCHIP_H2: port FCHIP_H2_FCHIP_H2, port FCHIP_H2_BGA_F3
  FCHIP_J17: port FCHIP_J17_FCHIP_J17
  FCHIP_J2: port FCHIP_J2_FCHIP_J2
  FCHIP_K17: port FCHIP_K17_FCHIP_K17, port FCHIP_K17_BGA_G11
  FCHIP_K2: port FCHIP_K2_FCHIP_K2, port FCHIP_K2_BGA_G2
  FCHIP_L17: port FCHIP_L17_FCHIP_L17
  FCHIP_L2: port FCHIP_L2_FCHIP_L2
  FCHIP_M17: port FCHIP_M17_FCHIP_M17, port FCHIP_M17_BGA_G10
  FCHIP_M2: port FCHIP_M2_FCHIP_M2, port FCHIP_M2_BGA_G3
  FCHIP_N17: port FCHIP_N17_FCHIP_N17
  FCHIP_N2: port FCHIP_N2_FCHIP_N2
  FCHIP_P17: port FCHIP_P17_FCHIP_P17
  FCHIP_P2: port FCHIP_P2_FCHIP_P2
  FCHIP_R17: port FCHIP_R17_FCHIP_R17
  FCHIP_R2: port FCHIP_R2_FCHIP_R2
  FCHIP_T17: port FCHIP_T17_FCHIP_T17
  FCHIP_T2: port FCHIP_T2_FCHIP_T2
  FCHIP_U13: port FCHIP_U13_FCHIP_U13, port FCHIP_U13_BGA_K7
  FCHIP_U14: port FCHIP_U14_FCHIP_U14, port FCHIP_U14_BGA_L8
  FCHIP_U16: port FCHIP_U16_FCHIP_U16, port FCHIP_U16_BGA_L9
  FCHIP_U3: port FCHIP_U3_FCHIP_U3, port FCHIP_U3_BGA_L4
  FCHIP_U5: port FCHIP_U5_FCHIP_U5, port FCHIP_U5_BGA_L5
  FCHIP_U6: port FCHIP_U6_FCHIP_U6, port FCHIP_U6_BGA_K6
  FCHIP_V1: port FCHIP_V1_FCHIP_V1, port FCHIP_V1_BGA_K3
  FCHIP_V12: port FCHIP_V12_FCHIP_V12
  FCHIP_V13: port FCHIP_V13_FCHIP_V13, port FCHIP_V13_BGA_L7
  FCHIP_V16: port FCHIP_V16_FCHIP_V16, port FCHIP_V16_BGA_M9
  FCHIP_V17: port FCHIP_V17_FCHIP_V17, port FCHIP_V17_BGA_M10
  FCHIP_V18: port FCHIP_V18_FCHIP_V18, port FCHIP_V18_BGA_K10
  FCHIP_V2: port FCHIP_V2_FCHIP_V2, port FCHIP_V2_BGA_M3
  FCHIP_V3: port FCHIP_V3_FCHIP_V3, port FCHIP_V3_BGA_M4
  FCHIP_V6: port FCHIP_V6_FCHIP_V6, port FCHIP_V6_BGA_L6
  FCHIP_V7: port FCHIP_V7_FCHIP_V7
  RXDATA0+: port RXDATA0+_FCHIP_B18, port RXDATA0+_BGA_B11
  RXDATA0-: port RXDATA0-_FCHIP_C18, port RXDATA0-_BGA_B12
  RXDATA1+: port RXDATA1+_FCHIP_E18, port RXDATA1+_BGA_C12
  RXDATA1-: port RXDATA1-_FCHIP_D18, port RXDATA1-_BGA_C11
  RXDATA2+: port RXDATA2+_FCHIP_G18, port RXDATA2+_BGA_E12
  RXDATA2-: port RXDATA2-_FCHIP_F18, port RXDATA2-_BGA_D12
  RXDATA3+: port RXDATA3+_FCHIP_J18, port RXDATA3+_BGA_G12
  RXDATA3-: port RXDATA3-_FCHIP_H18, port RXDATA3-_BGA_F12
  RXDATA4+: port RXDATA4+_FCHIP_L18, port RXDATA4+_BGA_J12
  RXDATA4-: port RXDATA4-_FCHIP_K18, port RXDATA4-_BGA_H12
  RXDATA5+: port RXDATA5+_FCHIP_M18, port RXDATA5+_BGA_K12
  RXDATA5-: port RXDATA5-_FCHIP_N18, port RXDATA5-_BGA_L12
  RXDATA6+: port RXDATA6+_FCHIP_P18, port RXDATA6+_BGA_J11
  RXDATA6-: port RXDATA6-_FCHIP_R18, port RXDATA6-_BGA_K11
  RXDATA7+: port RXDATA7+_FCHIP_T18, port RXDATA7+_BGA_L11
  RXDATA7-: port RXDATA7-_FCHIP_U18, port RXDATA7-_BGA_L10
  TXDATA0+: port TXDATA0+_FCHIP_B1, port TXDATA0+_BGA_B2
  TXDATA0-: port TXDATA0-_FCHIP_C1, port TXDATA0-_BGA_B1
  TXDATA1+: port TXDATA1+_FCHIP_D1, port TXDATA1+_BGA_C2
  TXDATA1-: port TXDATA1-_FCHIP_E1, port TXDATA1-_BGA_C1
  TXDATA2+: port TXDATA2+_FCHIP_F1, port TXDATA2+_BGA_D1
  TXDATA2-: port TXDATA2-_FCHIP_G1, port TXDATA2-_BGA_E1
  TXDATA3+: port TXDATA3+_FCHIP_H1, port TXDATA3+_BGA_F1
  TXDATA3-: port TXDATA3-_FCHIP_J1, port TXDATA3-_BGA_G1
  TXDATA4+: port TXDATA4+_FCHIP_K1, port TXDATA4+_BGA_H1
  TXDATA4-: port TXDATA4-_FCHIP_L1, port TXDATA4-_BGA_J1
  TXDATA5+: port TXDATA5+_FCHIP_M1, port TXDATA5+_BGA_K1
  TXDATA5-: port TXDATA5-_FCHIP_N1, port TXDATA5-_BGA_L1
  TXDATA6+: port TXDATA6+_FCHIP_P1, port TXDATA6+_BGA_J2
  TXDATA6-: port TXDATA6-_FCHIP_R1, port TXDATA6-_BGA_K2
  TXDATA7+: port TXDATA7+_FCHIP_U1, port TXDATA7+_BGA_L3
  TXDATA7-: port TXDATA7-_FCHIP_T1, port TXDATA7-_BGA_L2
  VDD_1: port VDD_1_FCHIP_P15
  VDD_10: port VDD_10_BGA_F6
  VDD_11: port VDD_11_BGA_G6
  VDD_12: port VDD_12_BGA_H6
  VDD_2: port VDD_2_FCHIP_E15
  VDD_3: port VDD_3_BGA_K9
  VDD_4: port VDD_4_BGA_K4
  VDD_5: port VDD_5_FCHIP_R15
  VDD_6: port VDD_6_FCHIP_D15
  VDD_7: port VDD_7_FCHIP_L15
  VDD_8: port VDD_8_FCHIP_H15
  VDD_9: port VDD_9_BGA_E6
  VSS_1: port VSS_1_BGA_E7
  VSS_2: port VSS_2_BGA_F5
  VSS_3: port VSS_3_BGA_F7
  VSS_4: port VSS_4_BGA_G5
  VSS_5: port VSS_5_BGA_G7
  VSS_6: port VSS_6_BGA_H5
  VSS_7: port VSS_7_BGA_H7
ports:
  FCHIP_A12_BGA_C7: Properties{Impedance=50ohm Magnitude=0V Phase=0deg Renormalize_Impedence=50ohm Deembed_Distance=0mm Layer_Alignment=Upper Horizontal_Extent_Factor=5 Vertical_Extent_Factor=3 PEC_Launch_Width=0mm Reference_Net=VDD} Type="Pad Port" Pin=FCHIP_A12_BGA_C7
  FCHIP_A12_FCHIP_A12: Properties{Impedance=50ohm Magnitude=0V Phase=0deg Renormalize_Impedence=50ohm Deembed_Distance=0mm Layer_Alignment=Lower Horizontal_Extent_Factor=5 Vertical_Extent_Factor=3 PEC_Launch_Width=0mm Reference_Net=VDD} Type="Pad Port" Pin=FCHIP_A12_FCHIP_A12
  FCHIP_A13_BGA_B7: Properties{Impedance=50ohm Magnitude=0V Phase=0deg Renormalize_Impedence=50ohm Deembed_Distance=0mm Layer_Alignment=Upper Horizontal_Extent_Factor=5 Vertical_Extent_Factor=3 PEC_Launch_Width=0mm Reference_Net=VDD} Type="Pad Port" Pin=FCHIP_A13_BGA_B7
  FCHIP_A13_FCHIP_A13: Properties{Impedance=50ohm Magnitude=0V Phase=0deg Renormalize_Impedence=50ohm Deembed_Distance=0mm Layer_Alignment=Lower Horizontal_Extent_Factor=5 Vertical_Extent_Factor=3 PEC_Launch_Width=0mm Reference_Net=VDD} Type="Pad Port" Pin=FCHIP_A13_FCHIP_A13
  FCHIP_A16_BGA_A10: Properties{Impedance=50ohm Magnitude=0V Phase=0deg Renormalize_Impedence=50ohm Deembed_Distance=0mm Layer_Alignment=Upper Horizontal_Extent_Factor=5 Vertical_Extent_Factor=3 PEC_Launch_Width=0mm Reference_Net=VDD} Type="Pad Port" Pin=FCHIP_A16_BGA_A10
  FCHIP_A16_FCHIP_A16: Properties{Impedance=50ohm Magnitude=0V Phase=0deg Renormalize_Impedence=50ohm Deembed_Distance=0mm Layer_Alignment=Lower Horizontal_Extent_Factor=5 Vertical_Extent_Factor=3 PEC_Launch_Width=0mm Reference_Net=VDD} Type="Pad Port" Pin=FCHIP_A16_FCHIP_A16
  FCHIP_A17_BGA_B10: Properties{Impedance=50ohm Magnitude=0V Phase=0deg Renormalize_Impedence=50ohm Deembed_Distance=0mm Layer_Alignment=Upper Horizontal_Extent_Factor=5 Vertical_Extent_Factor=3 PEC_Launch_Width=0mm Reference_Net=VDD} Type="Pad Port" Pin=FCHIP_A17_BGA_B10
  FCHIP_A17_FCHIP_A17: Properties{Impedance=50ohm Magnitude=0V Phase=0deg Renormalize_Impedence=50ohm Deembed_Distance=0mm Layer_Alignment=Lower Horizontal_Extent_Factor=5 Vertical_Extent_Factor=3 PEC_Launch_Width=0mm Reference_Net=VDD} Type="Pad Port" Pin=FCHIP_A17_FCHIP_A17
  FCHIP_A18_BGA_C10: Properties{Impedance=50ohm Magnitude=0V Phase=0deg Renormalize_Impedence=50ohm Deembed_Distance=0mm Layer_Alignment=Upper Horizontal_Extent_Factor=5 Vertical_Extent_Factor=3 PEC_Launch_Width=0mm Reference_Net=VDD} Type="Pad Port" Pin=FCHIP_A18_BGA_C10
  FCHIP_A18_FCHIP_A18: Properties{Impedance=50ohm Magnitude=0V Phase=0deg Renormalize_Impedence=50ohm Deembed_Distance=0mm Layer_Alignment=Lower Horizontal_Extent_Factor=5 Vertical_Extent_Factor=3 PEC_Launch_Width=0mm Reference_Net=VDD} Type="Pad Port" Pin=FCHIP_A18_FCHIP_A18
  FCHIP_A1_BGA_C3: Properties{Impedance=50ohm Magnitude=0V Phase=0deg Renormalize_Impedence=50ohm Deembed_Distance=0mm Layer_Alignment=Upper Horizontal_Extent_Factor=5 Vertical_Extent_Factor=3 PEC_Launch_Width=0mm Reference_Net=VDD} Type="Pad Port" Pin=FCHIP_A1_BGA_C3
  FCHIP_A1_FCHIP_A1: Properties{Impedance=50ohm Magnitude=0V Phase=0deg Renormalize_Impedence=50ohm Deembed_Distance=0mm Layer_Alignment=Lower Horizontal_Extent_Factor=5 Vertical_Extent_Factor=3 PEC_Launch_Width=0mm Reference_Net=VDD} Type="Pad Port" Pin=FCHIP_A1_FCHIP_A1
  FCHIP_A2_BGA_B3: Properties{Impedance=50ohm Magnitude=0V Phase=0deg Renormalize_Impedence=50ohm Deembed_Distance=0mm Layer_Alignment=Upper Horizontal_Extent_Factor=5 Vertical_Extent_Factor=3 PEC_Launch_Width=0mm Reference_Net=VDD} Type="Pad Port" Pin=FCHIP_A2_BGA_B3
  FCHIP_A2_FCHIP_A2: Properties{Impedance=50ohm Magnitude=0V Phase=0deg Renormalize_Impedence=50ohm Deembed_Distance=0mm Layer_Alignment=Lower Horizontal_Extent_Factor=5 Vertical_Extent_Factor=3 PEC_Launch_Width=0mm Reference_Net=VDD} Type="Pad Port" Pin=FCHIP_A2_FCHIP_A2
  FCHIP_A3_BGA_A3: Properties{Impedance=50ohm Magnitude=0V Phase=0deg Renormalize_Impedence=50ohm Deembed_Distance=0mm Layer_Alignment=Upper Horizontal_Extent_Factor=5 Vertical_Extent_Factor=3 PEC_Launch_Width=0mm Reference_Net=VDD} Type="Pad Port" Pin=FCHIP_A3_BGA_A3
  FCHIP_A3_FCHIP_A3: Properties{Impedance=50ohm Magnitude=0V Phase=0deg Renormalize_Impedence=50ohm Deembed_Distance=0mm Layer_Alignment=Lower Horizontal_Extent_Factor=5 Vertical_Extent_Factor=3 PEC_Launch_Width=0mm Reference_Net=VDD} Type="Pad Port" Pin=FCHIP_A3_FCHIP_A3
  FCHIP_A6_BGA_B6: Properties{Impedance=50ohm Magnitude=0V Phase=0deg Renormalize_Impedence=50ohm Deembed_Distance=0mm Layer_Alignment=Upper Horizontal_Extent_Factor=5 Vertical_Extent_Factor=3 PEC_Launch_Width=0mm Reference_Net=VDD} Type="Pad Port" Pin=FCHIP_A6_BGA_B6
  FCHIP_A6_FCHIP_A6: Properties{Impedance=50ohm Magnitude=0V Phase=0deg Renormalize_Impedence=50ohm Deembed_Distance=0mm Layer_Alignment=Lower Horizontal_Extent_Factor=5 Vertical_Extent_Factor=3 PEC_Launch_Width=0mm Reference_Net=VDD} Type="Pad Port" Pin=FCHIP_A6_FCHIP_A6
  FCHIP_A7_BGA_C6: Properties{Impedance=50ohm Magnitude=0V Phase=0deg Renormalize_Impedence=50ohm Deembed_Distance=0mm Layer_Alignment=Upper Horizontal_Extent_Factor=5 Vertical_Extent_Factor=3 PEC_Launch_Width=0mm Reference_Net=VDD} Type="Pad Port" Pin=FCHIP_A7_BGA_C6
  FCHIP_A7_FCHIP_A7: Properties{Impedance=50ohm Magnitude=0V Phase=0deg Renormalize_Impedence=50ohm Deembed_Distance=0mm Layer_Alignment=Lower Horizontal_Extent_Factor=5 Vertical_Extent_Factor=3 PEC_Launch_Width=0mm Reference_Net=VDD} Type="Pad Port" Pin=FCHIP_A7_FCHIP_A7
  FCHIP_B13_BGA_B8: Properties{Impedance=50ohm Magnitude=0V Phase=0deg Renormalize_Impedence=50ohm Deembed_Distance=0mm Layer_Alignment=Upper Horizontal_Extent_Factor=5 Vertical_Extent_Factor=3 PEC_Launch_Width=0mm Reference_Net=VDD} Type="Pad Port" Pin=FCHIP_B13_BGA_B8
  FCHIP_B13_FCHIP_B13: Properties{Impedance=50ohm Magnitude=0V Phase=0deg Renormalize_Impedence=50ohm Deembed_Distance=0mm Layer_Alignment=Lower Horizontal_Extent_Factor=5 Vertical_Extent_Factor=3 PEC_Launch_Width=0mm Reference_Net=VDD} Type="Pad Port" Pin=FCHIP_B13_FCHIP_B13
  FCHIP_B14_BGA_A9: Properties{Impedance=50ohm Magnitude=0V Phase=0deg Renormalize_Impedence=50ohm Deembed_Distance=0mm Layer_Alignment=Upper Horizontal_Extent_Factor=5 Vertical_Extent_Factor=3 PEC_Launch_Width=0mm Reference_Net=VDD} Type="Pad Port" Pin=FCHIP_B14_BGA_A9
  FCHIP_B14_FCHIP_B14: Properties{Impedance=50ohm Magnitude=0V Phase=0deg Renormalize_Impedence=50ohm Deembed_Distance=0mm Layer_Alignment=Lower Horizontal_Extent_Factor=5 Vertical_Extent_Factor=3 PEC_Launch_Width=0mm Reference_Net=VDD} Type="Pad Port" Pin=FCHIP_B14_FCHIP_B14
  FCHIP_B15_BGA_B9: Properties{Impedance=50ohm Magnitude=0V Phase=0deg Renormalize_Impedence=50ohm Deembed_Distance=0mm Layer_Alignment=Upper Horizontal_Extent_Factor=5 Vertical_Extent_Factor=3 PEC_Launch_Width=0mm Reference_Net=VDD} Type="Pad Port" Pin=FCHIP_B15_BGA_B9
  FCHIP_B15_FCHIP_B15: Properties{Impedance=50ohm Magnitude=0V Phase=0deg Renormalize_Impedence=50ohm Deembed_Distance=0mm Layer_Alignment=Lower Horizontal_Extent_Factor=5 Vertical_Extent_Factor=3 PEC_Launch_Width=0mm Reference_Net=VDD} Type="Pad Port" Pin=FCHIP_B15_FCHIP_B15
  FCHIP_B16_BGA_C9: Properties{Impedance=50ohm Magnitude=0V Phase=0deg Renormalize_Impedence=50ohm Deembed_Distance=0mm Layer_Alignment=Upper Horizontal_Extent_Factor=5 Vertical_Extent_Factor=3 PEC_Launch_Width=0mm Reference_Net=VDD} Type="Pad Port" Pin=FCHIP_B16_BGA_C9
  FCHIP_B16_FCHIP_B16: Properties{Impedance=50ohm Magnitude=0V Phase=0deg Renormalize_Impedence=50ohm Deembed_Distance=0mm Layer_Alignment=Lower Horizontal_Extent_Factor=5 Vertical_Extent_Factor=3 PEC_Launch_Width=0mm Reference_Net=VDD} Type="Pad Port" Pin=FCHIP_B16_FCHIP_B16
  FCHIP_B3_BGA_C4: Properties{Impedance=50ohm Magnitude=0V Phase=0deg Renormalize_Impedence=50ohm Deembed_Distance=0mm Layer_Alignment=Upper Horizontal_Extent_Factor=5 Vertical_Extent_Factor=3 PEC_Launch_Width=0mm Reference_Net=VDD} Type="Pad Port" Pin=FCHIP_B3_BGA_C4
  FCHIP_B3_FCHIP_B3: Properties{Impedance=50ohm Magnitude=0V Phase=0deg Renormalize_Impedence=50ohm Deembed_Distance=0mm Layer_Alignment=Lower Horizontal_Extent_Factor=5 Vertical_Extent_Factor=3 PEC_Launch_Width=0mm Reference_Net=VDD} Type="Pad Port" Pin=FCHIP_B3_FCHIP_B3
  FCHIP_B4_BGA_B4: Properties{Impedance=50ohm Magnitude=0V Phase=0deg Renormalize_Impedence=50ohm Deembed_Distance=0mm Layer_Alignment=Upper Horizontal_Extent_Factor=5 Vertical_Extent_Factor=3 PEC_Launch_Width=0mm Reference_Net=VDD} Type="Pad Port" Pin=FCHIP_B4_BGA_B4
  FCHIP_B4_FCHIP_B4: Properties{Impedance=50ohm Magnitude=0V Phase=0deg Renormalize_Impedence=50ohm Deembed_Distance=0mm Layer_Alignment=Lower Horizontal_Extent_Factor=5 Vertical_Extent_Factor=3 PEC_Launch_Width=0mm Reference_Net=VDD} Type="Pad Port" Pin=FCHIP_B4_FCHIP_B4
  FCHIP_B5_BGA_A4: Properties{Impedance=50ohm Magnitude=0V Phase=0deg Renormalize_Impedence=50ohm Deembed_Distance=0mm Layer_Alignment=Upper Horizontal_Extent_Factor=5 Vertical_Extent_Factor=3 PEC_Launch_Width=0mm Reference_Net=VDD} Type="Pad Port" Pin=FCHIP_B5_BGA_A4
  FCHIP_B5_FCHIP_B5: Properties{Impedance=50ohm Magnitude=0V Phase=0deg Renormalize_Impedence=50ohm Deembed_Distance=0mm Layer_Alignment=Lower Horizontal_Extent_Factor=5 Vertical_Extent_Factor=3 PEC_Launch_Width=0mm Reference_Net=VDD} Type="Pad Port" Pin=FCHIP_B5_FCHIP_B5
  FCHIP_B6_BGA_B5: Properties{Impedance=50ohm Magnitude=0V Phase=0deg Renormalize_Impedence=50ohm Deembed_Distance=0mm Layer_Alignment=Upper Horizontal_Extent_Factor=5 Vertical_Extent_Factor=3 PEC_Launch_Width=0mm Reference_Net=VDD} Type="Pad Port" Pin=FCHIP_B6_BGA_B5
  FCHIP_B6_FCHIP_B6: Properties{Impedance=50ohm Magnitude=0V Phase=0deg Renormalize_Impedence=50ohm Deembed_Distance=0mm Layer_Alignment=Lower Horizontal_Extent_Factor=5 Vertical_Extent_Factor=3 PEC_Launch_Width=0mm Reference_Net=VDD} Type="Pad Port" Pin=FCHIP_B6_FCHIP_B6
  FCHIP_C17_BGA_D11: Properties{Impedance=50ohm Magnitude=0V Phase=0deg Renormalize_Impedence=50ohm Deembed_Distance=0mm Layer_Alignment=Upper Horizontal_Extent_Factor=5 Vertical_Extent_Factor=3 PEC_Launch_Width=0mm Reference_Net=VDD} Type="Pad Port" Pin=FCHIP_C17_BGA_D11
  FCHIP_C17_FCHIP_C17: Properties{Impedance=50ohm Magnitude=0V Phase=0deg Renormalize_Impedence=50ohm Deembed_Distance=0mm Layer_Alignment=Lower Horizontal_Extent_Factor=5 Vertical_Extent_Factor=3 PEC_Launch_Width=0mm Reference_Net=VDD} Type="Pad Port" Pin=FCHIP_C17_FCHIP_C17
  FCHIP_C2_BGA_D2: Properties{Impedance=50ohm Magnitude=0V Phase=0deg Renormalize_Impedence=50ohm Deembed_Distance=0mm Layer_Alignment=Upper Horizontal_Extent_Factor=5 Vertical_Extent_Factor=3 PEC_Launch_Width=0mm Reference_Net=VDD} Type="Pad Port" Pin=FCHIP_C2_BGA_D2
  FCHIP_C2_FCHIP_C2: Properties{Impedance=50ohm Magnitude=0V Phase=0deg Renormalize_Impedence=50ohm Deembed_Distance=0mm Layer_Alignment=Lower Horizontal_Extent_Factor=5 Vertical_Extent_Factor=3 PEC_Launch_Width=0mm Reference_Net=VDD} Type="Pad Port" Pin=FCHIP_C2_FCHIP_C2
  FCHIP_D17_FCHIP_D17: Properties{Impedance=50ohm Magnitude=0V Phase=0deg Renormalize_Impedence=50ohm Deembed_Distance=0mm Layer_Alignment=Lower Horizontal_Extent_Factor=5 Vertical_Extent_Factor=3 PEC_Launch_Width=0mm Reference_Net=VDD} Type="Pad Port" Pin=FCHIP_D17_FCHIP_D17
  FCHIP_D2_FCHIP_D2: Properties{Impedance=50ohm Magnitude=0V Phase=0deg Renormalize_Impedence=50ohm Deembed_Distance=0mm Layer_Alignment=Lower Horizontal_Extent_Factor=5 Vertical_Extent_Factor=3 PEC_Launch_Width=0mm Reference_Net=VDD} Type="Pad Port" Pin=FCHIP_D2_FCHIP_D2
  FCHIP_E17_FCHIP_E17: Properties{Impedance=50ohm Magnitude=0V Phase=0deg Renormalize_Impedence=50ohm Deembed_Distance=0mm Layer_Alignment=Lower Horizontal_Extent_Factor=5 Vertical_Extent_Factor=3 PEC_Launch_Width=0mm Reference_Net=VDD} Type="Pad Port" Pin=FCHIP_E17_FCHIP_E17
  FCHIP_E2_FCHIP_E2: Properties{Impedance=50ohm Magnitude=0V Phase=0deg Renormalize_Impedence=50ohm Deembed_Distance=0mm Layer_Alignment=Lower Horizontal_Extent_Factor=5 Vertical_Extent_Factor=3 PEC_Launch_Width=0mm Reference_Net=VDD} Type="Pad Port" Pin=FCHIP_E2_FCHIP_E2
  FCHIP_F17_BGA_E11: Properties{Impedance=50ohm Magnitude=0V Phase=0deg Renormalize_Impedence=50ohm Deembed_Distance=0mm Layer_Alignment=Upper Horizontal_Extent_Factor=5 Vertical_Extent_Factor=3 PEC_Launch_Width=0mm Reference_Net=VDD} Type="Pad Port" Pin=FCHIP_F17_BGA_E11
  FCHIP_F17_FCHIP_F17: Properties{Impedance=50ohm Magnitude=0V Phase=0deg Renormalize_Impedence=50ohm Deembed_Distance=0mm Layer_Alignment=Lower Horizontal_Extent_Factor=5 Vertical_Extent_Factor=3 PEC_Launch_Width=0mm Reference_Net=VDD} Type="Pad Port" Pin=FCHIP_F17_FCHIP_F17
  FCHIP_F2_BGA_E2: Properties{Impedance=50ohm Magnitude=0V Phase=0deg Renormalize_Impedence=50ohm Deembed_Distance=0mm Layer_Alignment=Upper Horizontal_Extent_Factor=5 Vertical_Extent_Factor=3 PEC_Launch_Width=0mm Reference_Net=VDD} Type="Pad Port" Pin=FCHIP_F2_BGA_E2
  FCHIP_F2_FCHIP_F2: Properties{Impedance=50ohm Magnitude=0V Phase=0deg Renormalize_Impedence=50ohm Deembed_Distance=0mm Layer_Alignment=Lower Horizontal_Extent_Factor=5 Vertical_Extent_Factor=3 PEC_Launch_Width=0mm Reference_Net=VDD} Type="Pad Port" Pin=FCHIP_F2_FCHIP_F2
  FCHIP_G17_FCHIP_G17: Properties{Impedance=50ohm Magnitude=0V Phase=0deg Renormalize_Impedence=50ohm Deembed_Distance=0mm Layer_Alignment=Lower Horizontal_Extent_Factor=5 Vertical_Extent_Factor=3 PEC_Launch_Width=0mm Reference_Net=VDD} Type="Pad Port" Pin=FCHIP_G17_FCHIP_G17
  FCHIP_G2_FCHIP_G2: Properties{Impedance=50ohm Magnitude=0V Phase=0deg Renormalize_Impedence=50ohm Deembed_Distance=0mm Layer_Alignment=Lower Horizontal_Extent_Factor=5 Vertical_Extent_Factor=3 PEC_Launch_Width=0mm Reference_Net=VDD} Type="Pad Port" Pin=FCHIP_G2_FCHIP_G2
  FCHIP_H17_BGA_F10: Properties{Impedance=50ohm Magnitude=0V Phase=0deg Renormalize_Impedence=50ohm Deembed_Distance=0mm Layer_Alignment=Upper Horizontal_Extent_Factor=5 Vertical_Extent_Factor=3 PEC_Launch_Width=0mm Reference_Net=VDD} Type="Pad Port" Pin=FCHIP_H17_BGA_F10
  FCHIP_H17_FCHIP_H17: Properties{Impedance=50ohm Magnitude=0V Phase=0deg Renormalize_Impedence=50ohm Deembed_Distance=0mm Layer_Alignment=Lower Horizontal_Extent_Factor=5 Vertical_Extent_Factor=3 PEC_Launch_Width=0mm Reference_Net=VDD} Type="Pad Port" Pin=FCHIP_H17_FCHIP_H17
  FCHIP_H2_BGA_F3: Properties{Impedance=50ohm Magnitude=0V Phase=0deg Renormalize_Impedence=50ohm Deembed_Distance=0mm Layer_Alignment=Upper Horizontal_Extent_Factor=5 Vertical_Extent_Factor=3 PEC_Launch_Width=0mm Reference_Net=VDD} Type="Pad Port" Pin=FCHIP_H2_BGA_F3
  FCHIP_H2_FCHIP_H2: Properties{Impedance=50ohm Magnitude=0V Phase=0deg Renormalize_Impedence=50ohm Deembed_Distance=0mm Layer_Alignment=Lower Horizontal_Extent_Factor=5 Vertical_Extent_Factor=3 PEC_Launch_Width=0mm Reference_Net=VDD} Type="Pad Port" Pin=FCHIP_H2_FCHIP_H2
  FCHIP_J17_FCHIP_J17: Properties{Impedance=50ohm Magnitude=0V Phase=0deg Renormalize_Impedence=50ohm Deembed_Distance=0mm Layer_Alignment=Lower Horizontal_Extent_Factor=5 Vertical_Extent_Factor=3 PEC_Launch_Width=0mm Reference_Net=VDD} Type="Pad Port" Pin=FCHIP_J17_FCHIP_J17
  FCHIP_J2_FCHIP_J2: Properties{Impedance=50ohm Magnitude=0V Phase=0deg Renormalize_Impedence=50ohm Deembed_Distance=0mm Layer_Alignment=Lower Horizontal_Extent_Factor=5 Vertical_Extent_Factor=3 PEC_Launch_Width=0mm Reference_Net=VDD} Type="Pad Port" Pin=FCHIP_J2_FCHIP_J2
  FCHIP_K17_BGA_G11: Properties{Impedance=50ohm Magnitude=0V Phase=0deg Renormalize_Impedence=50ohm Deembed_Distance=0mm Layer_Alignment=Upper Horizontal_Extent_Factor=5 Vertical_Extent_Factor=3 PEC_Launch_Width=0mm Reference_Net=VDD} Type="Pad Port" Pin=FCHIP_K17_BGA_G11
  FCHIP_K17_FCHIP_K17: Properties{Impedance=50ohm Magnitude=0V Phase=0deg Renormalize_Impedence=50ohm Deembed_Distance=0mm Layer_Alignment=Lower Horizontal_Extent_Factor=5 Vertical_Extent_Factor=3 PEC_Launch_Width=0mm Reference_Net=VDD} Type="Pad Port" Pin=FCHIP_K17_FCHIP_K17
  FCHIP_K2_BGA_G2: Properties{Impedance=50ohm Magnitude=0V Phase=0deg Renormalize_Impedence=50ohm Deembed_Distance=0mm Layer_Alignment=Upper Horizontal_Extent_Factor=5 Vertical_Extent_Factor=3 PEC_Launch_Width=0mm Reference_Net=VDD} Type="Pad Port" Pin=FCHIP_K2_BGA_G2
  FCHIP_K2_FCHIP_K2: Properties{Impedance=50ohm Magnitude=0V Phase=0deg Renormalize_Impedence=50ohm Deembed_Distance=0mm Layer_Alignment=Lower Horizontal_Extent_Factor=5 Vertical_Extent_Factor=3 PEC_Launch_Width=0mm Reference_Net=VDD} Type="Pad Port" Pin=FCHIP_K2_FCHIP_K2
  FCHIP_L17_FCHIP_L17: Properties{Impedance=50ohm Magnitude=0V Phase=0deg Renormalize_Impedence=50ohm Deembed_Distance=0mm Layer_Alignment=Lower Horizontal_Extent_Factor=5 Vertical_Extent_Factor=3 PEC_Launch_Width=0mm Reference_Net=VDD} Type="Pad Port" Pin=FCHIP_L17_FCHIP_L17
  FCHIP_L2_FCHIP_L2: Properties{Impedance=50ohm Magnitude=0V Phase=0deg Renormalize_Impedence=50ohm Deembed_Distance=0mm Layer_Alignment=Lower Horizontal_Extent_Factor=5 Vertical_Extent_Factor=3 PEC_Launch_Width=0mm Reference_Net=VDD} Type="Pad Port" Pin=FCHIP_L2_FCHIP_L2
  FCHIP_M17_BGA_G10: Properties{Impedance=50ohm Magnitude=0V Phase=0deg Renormalize_Impedence=50ohm Deembed_Distance=0mm Layer_Alignment=Upper Horizontal_Extent_Factor=5 Vertical_Extent_Factor=3 PEC_Launch_Width=0mm Reference_Net=VDD} Type="Pad Port" Pin=FCHIP_M17_BGA_G10
  FCHIP_M17_FCHIP_M17: Properties{Impedance=50ohm Magnitude=0V Phase=0deg Renormalize_Impedence=50ohm Deembed_Distance=0mm Layer_Alignment=Lower Horizontal_Extent_Factor=5 Vertical_Extent_Factor=3 PEC_Launch_Width=0mm Reference_Net=VDD} Type="Pad Port" Pin=FCHIP_M17_FCHIP_M17
  FCHIP_M2_BGA_G3: Properties{Impedance=50ohm Magnitude=0V Phase=0deg Renormalize_Impedence=50ohm Deembed_Distance=0mm Layer_Alignment=Upper Horizontal_Extent_Factor=5 Vertical_Extent_Factor=3 PEC_Launch_Width=0mm Reference_Net=VDD} Type="Pad Port" Pin=FCHIP_M2_BGA_G3
  FCHIP_M2_FCHIP_M2: Properties{Impedance=50ohm Magnitude=0V Phase=0deg Renormalize_Impedence=50ohm Deembed_Distance=0mm Layer_Alignment=Lower Horizontal_Extent_Factor=5 Vertical_Extent_Factor=3 PEC_Launch_Width=0mm Reference_Net=VDD} Type="Pad Port" Pin=FCHIP_M2_FCHIP_M2
  FCHIP_N17_FCHIP_N17: Properties{Impedance=50ohm Magnitude=0V Phase=0deg Renormalize_Impedence=50ohm Deembed_Distance=0mm Layer_Alignment=Lower Horizontal_Extent_Factor=5 Vertical_Extent_Factor=3 PEC_Launch_Width=0mm Reference_Net=VDD} Type="Pad Port" Pin=FCHIP_N17_FCHIP_N17
  FCHIP_N2_FCHIP_N2: Properties{Impedance=50ohm Magnitude=0V Phase=0deg Renormalize_Impedence=50ohm Deembed_Distance=0mm Layer_Alignment=Lower Horizontal_Extent_Factor=5 Vertical_Extent_Factor=3 PEC_Launch_Width=0mm Reference_Net=VDD} Type="Pad Port" Pin=FCHIP_N2_FCHIP_N2
  FCHIP_P17_FCHIP_P17: Properties{Impedance=50ohm Magnitude=0V Phase=0deg Renormalize_Impedence=50ohm Deembed_Distance=0mm Layer_Alignment=Lower Horizontal_Extent_Factor=5 Vertical_Extent_Factor=3 PEC_Launch_Width=0mm Reference_Net=VDD} Type="Pad Port" Pin=FCHIP_P17_FCHIP_P17
  FCHIP_P2_FCHIP_P2: Properties{Impedance=50ohm Magnitude=0V Phase=0deg Renormalize_Impedence=50ohm Deembed_Distance=0mm Layer_Alignment=Lower Horizontal_Extent_Factor=5 Vertical_Extent_Factor=3 PEC_Launch_Width=0mm Reference_Net=VDD} Type="Pad Port" Pin=FCHIP_P2_FCHIP_P2
  FCHIP_R17_FCHIP_R17: Properties{Impedance=50ohm Magnitude=0V Phase=0deg Renormalize_Impedence=50ohm Deembed_Distance=0mm Layer_Alignment=Lower Horizontal_Extent_Factor=5 Vertical_Extent_Factor=3 PEC_Launch_Width=0mm Reference_Net=VDD} Type="Pad Port" Pin=FCHIP_R17_FCHIP_R17
  FCHIP_R2_FCHIP_R2: Properties{Impedance=50ohm Magnitude=0V Phase=0deg Renormalize_Impedence=50ohm Deembed_Distance=0mm Layer_Alignment=Lower Horizontal_Extent_Factor=5 Vertical_Extent_Factor=3 PEC_Launch_Width=0mm Reference_Net=VDD} Type="Pad Port" Pin=FCHIP_R2_FCHIP_R2
  FCHIP_T17_FCHIP_T17: Properties{Impedance=50ohm Magnitude=0V Phase=0deg Renormalize_Impedence=50ohm Deembed_Distance=0mm Layer_Alignment=Lower Horizontal_Extent_Factor=5 Vertical_Extent_Factor=3 PEC_Launch_Width=0mm Reference_Net=VDD} Type="Pad Port" Pin=FCHIP_T17_FCHIP_T17
  FCHIP_T2_FCHIP_T2: Properties{Impedance=50ohm Magnitude=0V Phase=0deg Renormalize_Impedence=50ohm Deembed_Distance=0mm Layer_Alignment=Lower Horizontal_Extent_Factor=5 Vertical_Extent_Factor=3 PEC_Launch_Width=0mm Reference_Net=VDD} Type="Pad Port" Pin=FCHIP_T2_FCHIP_T2
  FCHIP_U13_BGA_K7: Properties{Impedance=50ohm Magnitude=0V Phase=0deg Renormalize_Impedence=50ohm Deembed_Distance=0mm Layer_Alignment=Upper Horizontal_Extent_Factor=5 Vertical_Extent_Factor=3 PEC_Launch_Width=0mm Reference_Net=VDD} Type="Pad Port" Pin=FCHIP_U13_BGA_K7
  FCHIP_U13_FCHIP_U13: Properties{Impedance=50ohm Magnitude=0V Phase=0deg Renormalize_Impedence=50ohm Deembed_Distance=0mm Layer_Alignment=Lower Horizontal_Extent_Factor=5 Vertical_Extent_Factor=3 PEC_Launch_Width=0mm Reference_Net=VDD} Type="Pad Port" Pin=FCHIP_U13_FCHIP_U13
  FCHIP_U14_BGA_L8: Properties{Impedance=50ohm Magnitude=0V Phase=0deg Renormalize_Impedence=50ohm Deembed_Distance=0mm Layer_Alignment=Upper Horizontal_Extent_Factor=5 Vertical_Extent_Factor=3 PEC_Launch_Width=0mm Reference_Net=VDD} Type="Pad Port" Pin=FCHIP_U14_BGA_L8
  FCHIP_U14_FCHIP_U14: Properties{Impedance=50ohm Magnitude=0V Phase=0deg Renormalize_Impedence=50ohm Deembed_Distance=0mm Layer_Alignment=Lower Horizontal_Extent_Factor=5 Vertical_Extent_Factor=3 PEC_Launch_Width=0mm Reference_Net=VDD} Type="Pad Port" Pin=FCHIP_U14_FCHIP_U14
  FCHIP_U16_BGA_L9: Properties{Impedance=50ohm Magnitude=0V Phase=0deg Renormalize_Impedence=50ohm Deembed_Distance=0mm Layer_Alignment=Upper Horizontal_Extent_Factor=5 Vertical_Extent_Factor=3 PEC_Launch_Width=0mm Reference_Net=VDD} Type="Pad Port" Pin=FCHIP_U16_BGA_L9
  FCHIP_U16_FCHIP_U16: Properties{Impedance=50ohm Magnitude=0V Phase=0deg Renormalize_Impedence=50ohm Deembed_Distance=0mm Layer_Alignment=Lower Horizontal_Extent_Factor=5 Vertical_Extent_Factor=3 PEC_Launch_Width=0mm Reference_Net=VDD} Type="Pad Port" Pin=FCHIP_U16_FCHIP_U16
  FCHIP_U3_BGA_L4: Properties{Impedance=50ohm Magnitude=0V Phase=0deg Renormalize_Impedence=50ohm Deembed_Distance=0mm Layer_Alignment=Upper Horizontal_Extent_Factor=5 Vertical_Extent_Factor=3 PEC_Launch_Width=0mm Reference_Net=VDD} Type="Pad Port" Pin=FCHIP_U3_BGA_L4
  FCHIP_U3_FCHIP_U3: Properties{Impedance=50ohm Magnitude=0V Phase=0deg Renormalize_Impedence=50ohm Deembed_Distance=0mm Layer_Alignment=Lower Horizontal_Extent_Factor=5 Vertical_Extent_Factor=3 PEC_Launch_Width=0mm Reference_Net=VDD} Type="Pad Port" Pin=FCHIP_U3_FCHIP_U3
  FCHIP_U5_BGA_L5: Properties{Impedance=50ohm Magnitude=0V Phase=0deg Renormalize_Impedence=50ohm Deembed_Distance=0mm Layer_Alignment=Upper Horizontal_Extent_Factor=5 Vertical_Extent_Factor=3 PEC_Launch_Width=0mm Reference_Net=VDD} Type="Pad Port" Pin=FCHIP_U5_BGA_L5
  FCHIP_U5_FCHIP_U5: Properties{Impedance=50ohm Magnitude=0V Phase=0deg Renormalize_Impedence=50ohm Deembed_Distance=0mm Layer_Alignment=Lower Horizontal_Extent_Factor=5 Vertical_Extent_Factor=3 PEC_Launch_Width=0mm Reference_Net=VDD} Type="Pad Port" Pin=FCHIP_U5_FCHIP_U5
  FCHIP_U6_BGA_K6: Properties{Impedance=50ohm Magnitude=0V Phase=0deg Renormalize_Impedence=50ohm Deembed_Distance=0mm Layer_Alignment=Upper Horizontal_Extent_Factor=5 Vertical_Extent_Factor=3 PEC_Launch_Width=0mm Reference_Net=VDD} Type="Pad Port" Pin=FCHIP_U6_BGA_K6
  FCHIP_U6_FCHIP_U6: Properties{Impedance=50ohm Magnitude=0V Phase=0deg Renormalize_Impedence=50ohm Deembed_Distance=0mm Layer_Alignment=Lower Horizontal_Extent_Factor=5 Vertical_Extent_Factor=3 PEC_Launch_Width=0mm Reference_Net=VDD} Type="Pad Port" Pin=FCHIP_U6_FCHIP_U6
  FCHIP_V12_FCHIP_V12: Properties{Impedance=50ohm Magnitude=0V Phase=0deg Renormalize_Impedence=50ohm Deembed_Distance=0mm Layer_Alignment=Lower Horizontal_Extent_Factor=5 Vertical_Extent_Factor=3 PEC_Launch_Width=0mm Reference_Net=VDD} Type="Pad Port" Pin=FCHIP_V12_FCHIP_V12
  FCHIP_V13_BGA_L7: Properties{Impedance=50ohm Magnitude=0V Phase=0deg Renormalize_Impedence=50ohm Deembed_Distance=0mm Layer_Alignment=Upper Horizontal_Extent_Factor=5 Vertical_Extent_Factor=3 PEC_Launch_Width=0mm Reference_Net=VDD} Type="Pad Port" Pin=FCHIP_V13_BGA_L7
  FCHIP_V13_FCHIP_V13: Properties{Impedance=50ohm Magnitude=0V Phase=0deg Renormalize_Impedence=50ohm Deembed_Distance=0mm Layer_Alignment=Lower Horizontal_Extent_Factor=5 Vertical_Extent_Factor=3 PEC_Launch_Width=0mm Reference_Net=VDD} Type="Pad Port" Pin=FCHIP_V13_FCHIP_V13
  FCHIP_V16_BGA_M9: Properties{Impedance=50ohm Magnitude=0V Phase=0deg Renormalize_Impedence=50ohm Deembed_Distance=0mm Layer_Alignment=Upper Horizontal_Extent_Factor=5 Vertical_Extent_Factor=3 PEC_Launch_Width=0mm Reference_Net=VDD} Type="Pad Port" Pin=FCHIP_V16_BGA_M9
  FCHIP_V16_FCHIP_V16: Properties{Impedance=50ohm Magnitude=0V Phase=0deg Renormalize_Impedence=50ohm Deembed_Distance=0mm Layer_Alignment=Lower Horizontal_Extent_Factor=5 Vertical_Extent_Factor=3 PEC_Launch_Width=0mm Reference_Net=VDD} Type="Pad Port" Pin=FCHIP_V16_FCHIP_V16
  FCHIP_V17_BGA_M10: Properties{Impedance=50ohm Magnitude=0V Phase=0deg Renormalize_Impedence=50ohm Deembed_Distance=0mm Layer_Alignment=Upper Horizontal_Extent_Factor=5 Vertical_Extent_Factor=3 PEC_Launch_Width=0mm Reference_Net=VDD} Type="Pad Port" Pin=FCHIP_V17_BGA_M10
  FCHIP_V17_FCHIP_V17: Properties{Impedance=50ohm Magnitude=0V Phase=0deg Renormalize_Impedence=50ohm Deembed_Distance=0mm Layer_Alignment=Lower Horizontal_Extent_Factor=5 Vertical_Extent_Factor=3 PEC_Launch_Width=0mm Reference_Net=VDD} Type="Pad Port" Pin=FCHIP_V17_FCHIP_V17
  FCHIP_V18_BGA_K10: Properties{Impedance=50ohm Magnitude=0V Phase=0deg Renormalize_Impedence=50ohm Deembed_Distance=0mm Layer_Alignment=Upper Horizontal_Extent_Factor=5 Vertical_Extent_Factor=3 PEC_Launch_Width=0mm Reference_Net=VDD} Type="Pad Port" Pin=FCHIP_V18_BGA_K10
  FCHIP_V18_FCHIP_V18: Properties{Impedance=50ohm Magnitude=0V Phase=0deg Renormalize_Impedence=50ohm Deembed_Distance=0mm Layer_Alignment=Lower Horizontal_Extent_Factor=5 Vertical_Extent_Factor=3 PEC_Launch_Width=0mm Reference_Net=VDD} Type="Pad Port" Pin=FCHIP_V18_FCHIP_V18
  FCHIP_V1_BGA_K3: Properties{Impedance=50ohm Magnitude=0V Phase=0deg Renormalize_Impedence=50ohm Deembed_Distance=0mm Layer_Alignment=Upper Horizontal_Extent_Factor=5 Vertical_Extent_Factor=3 PEC_Launch_Width=0mm Reference_Net=VDD} Type="Pad Port" Pin=FCHIP_V1_BGA_K3
  FCHIP_V1_FCHIP_V1: Properties{Impedance=50ohm Magnitude=0V Phase=0deg Renormalize_Impedence=50ohm Deembed_Distance=0mm Layer_Alignment=Lower Horizontal_Extent_Factor=5 Vertical_Extent_Factor=3 PEC_Launch_Width=0mm Reference_Net=VDD} Type="Pad Port" Pin=FCHIP_V1_FCHIP_V1
  FCHIP_V2_BGA_M3: Properties{Impedance=50ohm Magnitude=0V Phase=0deg Renormalize_Impedence=50ohm Deembed_Distance=0mm Layer_Alignment=Upper Horizontal_Extent_Factor=5 Vertical_Extent_Factor=3 PEC_Launch_Width=0mm Reference_Net=VDD} Type="Pad Port" Pin=FCHIP_V2_BGA_M3
  FCHIP_V2_FCHIP_V2: Properties{Impedance=50ohm Magnitude=0V Phase=0deg Renormalize_Impedence=50ohm Deembed_Distance=0mm Layer_Alignment=Lower Horizontal_Extent_Factor=5 Vertical_Extent_Factor=3 PEC_Launch_Width=0mm Reference_Net=VDD} Type="Pad Port" Pin=FCHIP_V2_FCHIP_V2
  FCHIP_V3_BGA_M4: Properties{Impedance=50ohm Magnitude=0V Phase=0deg Renormalize_Impedence=50ohm Deembed_Distance=0mm Layer_Alignment=Upper Horizontal_Extent_Factor=5 Vertical_Extent_Factor=3 PEC_Launch_Width=0mm Reference_Net=VDD} Type="Pad Port" Pin=FCHIP_V3_BGA_M4
  FCHIP_V3_FCHIP_V3: Properties{Impedance=50ohm Magnitude=0V Phase=0deg Renormalize_Impedence=50ohm Deembed_Distance=0mm Layer_Alignment=Lower Horizontal_Extent_Factor=5 Vertical_Extent_Factor=3 PEC_Launch_Width=0mm Reference_Net=VDD} Type="Pad Port" Pin=FCHIP_V3_FCHIP_V3
  FCHIP_V6_BGA_L6: Properties{Impedance=50ohm Magnitude=0V Phase=0deg Renormalize_Impedence=50ohm Deembed_Distance=0mm Layer_Alignment=Upper Horizontal_Extent_Factor=5 Vertical_Extent_Factor=3 PEC_Launch_Width=0mm Reference_Net=VDD} Type="Pad Port" Pin=FCHIP_V6_BGA_L6
  FCHIP_V6_FCHIP_V6: Properties{Impedance=50ohm Magnitude=0V Phase=0deg Renormalize_Impedence=50ohm Deembed_Distance=0mm Layer_Alignment=Lower Horizontal_Extent_Factor=5 Vertical_Extent_Factor=3 PEC_Launch_Width=0mm Reference_Net=VDD} Type="Pad Port" Pin=FCHIP_V6_FCHIP_V6
  FCHIP_V7_FCHIP_V7: Properties{Impedance=50ohm Magnitude=0V Phase=0deg Renormalize_Impedence=50ohm Deembed_Distance=0mm Layer_Alignment=Lower Horizontal_Extent_Factor=5 Vertical_Extent_Factor=3 PEC_Launch_Width=0mm Reference_Net=VDD} Type="Pad Port" Pin=FCHIP_V7_FCHIP_V7
  RXDATA0+_BGA_B11: Properties{Impedance=50ohm Magnitude=0V Phase=0deg Renormalize_Impedence=50ohm Deembed_Distance=0mm Layer_Alignment=Upper Horizontal_Extent_Factor=5 Vertical_Extent_Factor=3 PEC_Launch_Width=0mm Reference_Net=VDD} Type="Pad Port" Pin=RXDATA0+_BGA_B11
  RXDATA0+_FCHIP_B18: Properties{Impedance=50ohm Magnitude=0V Phase=0deg Renormalize_Impedence=50ohm Deembed_Distance=0mm Layer_Alignment=Lower Horizontal_Extent_Factor=5 Vertical_Extent_Factor=3 PEC_Launch_Width=0mm Reference_Net=VDD} Type="Pad Port" Pin=RXDATA0+_FCHIP_B18
  RXDATA0-_BGA_B12: Properties{Impedance=50ohm Magnitude=0V Phase=0deg Renormalize_Impedence=50ohm Deembed_Distance=0mm Layer_Alignment=Upper Horizontal_Extent_Factor=5 Vertical_Extent_Factor=3 PEC_Launch_Width=0mm Reference_Net=VDD} Type="Pad Port" Pin=RXDATA0-_BGA_B12
  RXDATA0-_FCHIP_C18: Properties{Impedance=50ohm Magnitude=0V Phase=0deg Renormalize_Impedence=50ohm Deembed_Distance=0mm Layer_Alignment=Lower Horizontal_Extent_Factor=5 Vertical_Extent_Factor=3 PEC_Launch_Width=0mm Reference_Net=VDD} Type="Pad Port" Pin=RXDATA0-_FCHIP_C18
  RXDATA1+_BGA_C12: Properties{Impedance=50ohm Magnitude=0V Phase=0deg Renormalize_Impedence=50ohm Deembed_Distance=0mm Layer_Alignment=Upper Horizontal_Extent_Factor=5 Vertical_Extent_Factor=3 PEC_Launch_Width=0mm Reference_Net=VDD} Type="Pad Port" Pin=RXDATA1+_BGA_C12
  RXDATA1+_FCHIP_E18: Properties{Impedance=50ohm Magnitude=0V Phase=0deg Renormalize_Impedence=50ohm Deembed_Distance=0mm Layer_Alignment=Lower Horizontal_Extent_Factor=5 Vertical_Extent_Factor=3 PEC_Launch_Width=0mm Reference_Net=VDD} Type="Pad Port" Pin=RXDATA1+_FCHIP_E18
  RXDATA1-_BGA_C11: Properties{Impedance=50ohm Magnitude=0V Phase=0deg Renormalize_Impedence=50ohm Deembed_Distance=0mm Layer_Alignment=Upper Horizontal_Extent_Factor=5 Vertical_Extent_Factor=3 PEC_Launch_Width=0mm Reference_Net=VDD} Type="Pad Port" Pin=RXDATA1-_BGA_C11
  RXDATA1-_FCHIP_D18: Properties{Impedance=50ohm Magnitude=0V Phase=0deg Renormalize_Impedence=50ohm Deembed_Distance=0mm Layer_Alignment=Lower Horizontal_Extent_Factor=5 Vertical_Extent_Factor=3 PEC_Launch_Width=0mm Reference_Net=VDD} Type="Pad Port" Pin=RXDATA1-_FCHIP_D18
  RXDATA2+_BGA_E12: Properties{Impedance=50ohm Magnitude=0V Phase=0deg Renormalize_Impedence=50ohm Deembed_Distance=0mm Layer_Alignment=Upper Horizontal_Extent_Factor=5 Vertical_Extent_Factor=3 PEC_Launch_Width=0mm Reference_Net=VDD} Type="Pad Port" Pin=RXDATA2+_BGA_E12
  RXDATA2+_FCHIP_G18: Properties{Impedance=50ohm Magnitude=0V Phase=0deg Renormalize_Impedence=50ohm Deembed_Distance=0mm Layer_Alignment=Lower Horizontal_Extent_Factor=5 Vertical_Extent_Factor=3 PEC_Launch_Width=0mm Reference_Net=VDD} Type="Pad Port" Pin=RXDATA2+_FCHIP_G18
  RXDATA2-_BGA_D12: Properties{Impedance=50ohm Magnitude=0V Phase=0deg Renormalize_Impedence=50ohm Deembed_Distance=0mm Layer_Alignment=Upper Horizontal_Extent_Factor=5 Vertical_Extent_Factor=3 PEC_Launch_Width=0mm Reference_Net=VDD} Type="Pad Port" Pin=RXDATA2-_BGA_D12
  RXDATA2-_FCHIP_F18: Properties{Impedance=50ohm Magnitude=0V Phase=0deg Renormalize_Impedence=50ohm Deembed_Distance=0mm Layer_Alignment=Lower Horizontal_Extent_Factor=5 Vertical_Extent_Factor=3 PEC_Launch_Width=0mm Reference_Net=VDD} Type="Pad Port" Pin=RXDATA2-_FCHIP_F18
  RXDATA3+_BGA_G12: Properties{Impedance=50ohm Magnitude=0V Phase=0deg Renormalize_Impedence=50ohm Deembed_Distance=0mm Layer_Alignment=Upper Horizontal_Extent_Factor=5 Vertical_Extent_Factor=3 PEC_Launch_Width=0mm Reference_Net=VDD} Type="Pad Port" Pin=RXDATA3+_BGA_G12
  RXDATA3+_FCHIP_J18: Properties{Impedance=50ohm Magnitude=0V Phase=0deg Renormalize_Impedence=50ohm Deembed_Distance=0mm Layer_Alignment=Lower Horizontal_Extent_Factor=5 Vertical_Extent_Factor=3 PEC_Launch_Width=0mm Reference_Net=VDD} Type="Pad Port" Pin=RXDATA3+_FCHIP_J18
  RXDATA3-_BGA_F12: Properties{Impedance=50ohm Magnitude=0V Phase=0deg Renormalize_Impedence=50ohm Deembed_Distance=0mm Layer_Alignment=Upper Horizontal_Extent_Factor=5 Vertical_Extent_Factor=3 PEC_Launch_Width=0mm Reference_Net=VDD} Type="Pad Port" Pin=RXDATA3-_BGA_F12
  RXDATA3-_FCHIP_H18: Properties{Impedance=50ohm Magnitude=0V Phase=0deg Renormalize_Impedence=50ohm Deembed_Distance=0mm Layer_Alignment=Lower Horizontal_Extent_Factor=5 Vertical_Extent_Factor=3 PEC_Launch_Width=0mm Reference_Net=VDD} Type="Pad Port" Pin=RXDATA3-_FCHIP_H18
  RXDATA4+_BGA_J12: Properties{Impedance=50ohm Magnitude=0V Phase=0deg Renormalize_Impedence=50ohm Deembed_Distance=0mm Layer_Alignment=Upper Horizontal_Extent_Factor=5 Vertical_Extent_Factor=3 PEC_Launch_Width=0mm Reference_Net=VDD} Type="Pad Port" Pin=RXDATA4+_BGA_J12
  RXDATA4+_FCHIP_L18: Properties{Impedance=50ohm Magnitude=0V Phase=0deg Renormalize_Impedence=50ohm Deembed_Distance=0mm Layer_Alignment=Lower Horizontal_Extent_Factor=5 Vertical_Extent_Factor=3 PEC_Launch_Width=0mm Reference_Net=VDD} Type="Pad Port" Pin=RXDATA4+_FCHIP_L18
  RXDATA4-_BGA_H12: Properties{Impedance=50ohm Magnitude=0V Phase=0deg Renormalize_Impedence=50ohm Deembed_Distance=0mm Layer_Alignment=Upper Horizontal_Extent_Factor=5 Vertical_Extent_Factor=3 PEC_Launch_Width=0mm Reference_Net=VDD} Type="Pad Port" Pin=RXDATA4-_BGA_H12
  RXDATA4-_FCHIP_K18: Properties{Impedance=50ohm Magnitude=0V Phase=0deg Renormalize_Impedence=50ohm Deembed_Distance=0mm Layer_Alignment=Lower Horizontal_Extent_Factor=5 Vertical_Extent_Factor=3 PEC_Launch_Width=0mm Reference_Net=VDD} Type="Pad Port" Pin=RXDATA4-_FCHIP_K18
  RXDATA5+_BGA_K12: Properties{Impedance=50ohm Magnitude=0V Phase=0deg Renormalize_Impedence=50ohm Deembed_Distance=0mm Layer_Alignment=Upper Horizontal_Extent_Factor=5 Vertical_Extent_Factor=3 PEC_Launch_Width=0mm Reference_Net=VDD} Type="Pad Port" Pin=RXDATA5+_BGA_K12
  RXDATA5+_FCHIP_M18: Properties{Impedance=50ohm Magnitude=0V Phase=0deg Renormalize_Impedence=50ohm Deembed_Distance=0mm Layer_Alignment=Lower Horizontal_Extent_Factor=5 Vertical_Extent_Factor=3 PEC_Launch_Width=0mm Reference_Net=VDD} Type="Pad Port" Pin=RXDATA5+_FCHIP_M18
  RXDATA5-_BGA_L12: Properties{Impedance=50ohm Magnitude=0V Phase=0deg Renormalize_Impedence=50ohm Deembed_Distance=0mm Layer_Alignment=Upper Horizontal_Extent_Factor=5 Vertical_Extent_Factor=3 PEC_Launch_Width=0mm Reference_Net=VDD} Type="Pad Port" Pin=RXDATA5-_BGA_L12
  RXDATA5-_FCHIP_N18: Properties{Impedance=50ohm Magnitude=0V Phase=0deg Renormalize_Impedence=50ohm Deembed_Distance=0mm Layer_Alignment=Lower Horizontal_Extent_Factor=5 Vertical_Extent_Factor=3 PEC_Launch_Width=0mm Reference_Net=VDD} Type="Pad Port" Pin=RXDATA5-_FCHIP_N18
  RXDATA6+_BGA_J11: Properties{Impedance=50ohm Magnitude=0V Phase=0deg Renormalize_Impedence=50ohm Deembed_Distance=0mm Layer_Alignment=Upper Horizontal_Extent_Factor=5 Vertical_Extent_Factor=3 PEC_Launch_Width=0mm Reference_Net=VDD} Type="Pad Port" Pin=RXDATA6+_BGA_J11
  RXDATA6+_FCHIP_P18: Properties{Impedance=50ohm Magnitude=0V Phase=0deg Renormalize_Impedence=50ohm Deembed_Distance=0mm Layer_Alignment=Lower Horizontal_Extent_Factor=5 Vertical_Extent_Factor=3 PEC_Launch_Width=0mm Reference_Net=VDD} Type="Pad Port" Pin=RXDATA6+_FCHIP_P18
  RXDATA6-_BGA_K11: Properties{Impedance=50ohm Magnitude=0V Phase=0deg Renormalize_Impedence=50ohm Deembed_Distance=0mm Layer_Alignment=Upper Horizontal_Extent_Factor=5 Vertical_Extent_Factor=3 PEC_Launch_Width=0mm Reference_Net=VDD} Type="Pad Port" Pin=RXDATA6-_BGA_K11
  RXDATA6-_FCHIP_R18: Properties{Impedance=50ohm Magnitude=0V Phase=0deg Renormalize_Impedence=50ohm Deembed_Distance=0mm Layer_Alignment=Lower Horizontal_Extent_Factor=5 Vertical_Extent_Factor=3 PEC_Launch_Width=0mm Reference_Net=VDD} Type="Pad Port" Pin=RXDATA6-_FCHIP_R18
  RXDATA7+_BGA_L11: Properties{Impedance=50ohm Magnitude=0V Phase=0deg Renormalize_Impedence=50ohm Deembed_Distance=0mm Layer_Alignment=Upper Horizontal_Extent_Factor=5 Vertical_Extent_Factor=3 PEC_Launch_Width=0mm Reference_Net=VDD} Type="Pad Port" Pin=RXDATA7+_BGA_L11
  RXDATA7+_FCHIP_T18: Properties{Impedance=50ohm Magnitude=0V Phase=0deg Renormalize_Impedence=50ohm Deembed_Distance=0mm Layer_Alignment=Lower Horizontal_Extent_Factor=5 Vertical_Extent_Factor=3 PEC_Launch_Width=0mm Reference_Net=VDD} Type="Pad Port" Pin=RXDATA7+_FCHIP_T18
  RXDATA7-_BGA_L10: Properties{Impedance=50ohm Magnitude=0V Phase=0deg Renormalize_Impedence=50ohm Deembed_Distance=0mm Layer_Alignment=Upper Horizontal_Extent_Factor=5 Vertical_Extent_Factor=3 PEC_Launch_Width=0mm Reference_Net=VDD} Type="Pad Port" Pin=RXDATA7-_BGA_L10
  RXDATA7-_FCHIP_U18: Properties{Impedance=50ohm Magnitude=0V Phase=0deg Renormalize_Impedence=50ohm Deembed_Distance=0mm Layer_Alignment=Lower Horizontal_Extent_Factor=5 Vertical_Extent_Factor=3 PEC_Launch_Width=0mm Reference_Net=VDD} Type="Pad Port" Pin=RXDATA7-_FCHIP_U18
  TXDATA0+_BGA_B2: Properties{Impedance=50ohm Magnitude=0V Phase=0deg Renormalize_Impedence=50ohm Deembed_Distance=0mm Layer_Alignment=Upper Horizontal_Extent_Factor=5 Vertical_Extent_Factor=3 PEC_Launch_Width=0mm Reference_Net=VDD} Type="Pad Port" Pin=TXDATA0+_BGA_B2
  TXDATA0+_FCHIP_B1: Properties{Impedance=50ohm Magnitude=0V Phase=0deg Renormalize_Impedence=50ohm Deembed_Distance=0mm Layer_Alignment=Lower Horizontal_Extent_Factor=5 Vertical_Extent_Factor=3 PEC_Launch_Width=0mm Reference_Net=VDD} Type="Pad Port" Pin=TXDATA0+_FCHIP_B1
  TXDATA0-_BGA_B1: Properties{Impedance=50ohm Magnitude=0V Phase=0deg Renormalize_Impedence=50ohm Deembed_Distance=0mm Layer_Alignment=Upper Horizontal_Extent_Factor=5 Vertical_Extent_Factor=3 PEC_Launch_Width=0mm Reference_Net=VDD} Type="Pad Port" Pin=TXDATA0-_BGA_B1
  TXDATA0-_FCHIP_C1: Properties{Impedance=50ohm Magnitude=0V Phase=0deg Renormalize_Impedence=50ohm Deembed_Distance=0mm Layer_Alignment=Lower Horizontal_Extent_Factor=5 Vertical_Extent_Factor=3 PEC_Launch_Width=0mm Reference_Net=VDD} Type="Pad Port" Pin=TXDATA0-_FCHIP_C1
  TXDATA1+_BGA_C2: Properties{Impedance=50ohm Magnitude=0V Phase=0deg Renormalize_Impedence=50ohm Deembed_Distance=0mm Layer_Alignment=Upper Horizontal_Extent_Factor=5 Vertical_Extent_Factor=3 PEC_Launch_Width=0mm Reference_Net=VDD} Type="Pad Port" Pin=TXDATA1+_BGA_C2
  TXDATA1+_FCHIP_D1: Properties{Impedance=50ohm Magnitude=0V Phase=0deg Renormalize_Impedence=50ohm Deembed_Distance=0mm Layer_Alignment=Lower Horizontal_Extent_Factor=5 Vertical_Extent_Factor=3 PEC_Launch_Width=0mm Reference_Net=VDD} Type="Pad Port" Pin=TXDATA1+_FCHIP_D1
  TXDATA1-_BGA_C1: Properties{Impedance=50ohm Magnitude=0V Phase=0deg Renormalize_Impedence=50ohm Deembed_Distance=0mm Layer_Alignment=Upper Horizontal_Extent_Factor=5 Vertical_Extent_Factor=3 PEC_Launch_Width=0mm Reference_Net=VDD} Type="Pad Port" Pin=TXDATA1-_BGA_C1
  TXDATA1-_FCHIP_E1: Properties{Impedance=50ohm Magnitude=0V Phase=0deg Renormalize_Impedence=50ohm Deembed_Distance=0mm Layer_Alignment=Lower Horizontal_Extent_Factor=5 Vertical_Extent_Factor=3 PEC_Launch_Width=0mm Reference_Net=VDD} Type="Pad Port" Pin=TXDATA1-_FCHIP_E1
  TXDATA2+_BGA_D1: Properties{Impedance=50ohm Magnitude=0V Phase=0deg Renormalize_Impedence=50ohm Deembed_Distance=0mm Layer_Alignment=Upper Horizontal_Extent_Factor=5 Vertical_Extent_Factor=3 PEC_Launch_Width=0mm Reference_Net=VDD} Type="Pad Port" Pin=TXDATA2+_BGA_D1
  TXDATA2+_FCHIP_F1: Properties{Impedance=50ohm Magnitude=0V Phase=0deg Renormalize_Impedence=50ohm Deembed_Distance=0mm Layer_Alignment=Lower Horizontal_Extent_Factor=5 Vertical_Extent_Factor=3 PEC_Launch_Width=0mm Reference_Net=VDD} Type="Pad Port" Pin=TXDATA2+_FCHIP_F1
  TXDATA2-_BGA_E1: Properties{Impedance=50ohm Magnitude=0V Phase=0deg Renormalize_Impedence=50ohm Deembed_Distance=0mm Layer_Alignment=Upper Horizontal_Extent_Factor=5 Vertical_Extent_Factor=3 PEC_Launch_Width=0mm Reference_Net=VDD} Type="Pad Port" Pin=TXDATA2-_BGA_E1
  TXDATA2-_FCHIP_G1: Properties{Impedance=50ohm Magnitude=0V Phase=0deg Renormalize_Impedence=50ohm Deembed_Distance=0mm Layer_Alignment=Lower Horizontal_Extent_Factor=5 Vertical_Extent_Factor=3 PEC_Launch_Width=0mm Reference_Net=VDD} Type="Pad Port" Pin=TXDATA2-_FCHIP_G1
  TXDATA3+_BGA_F1: Properties{Impedance=50ohm Magnitude=0V Phase=0deg Renormalize_Impedence=50ohm Deembed_Distance=0mm Layer_Alignment=Upper Horizontal_Extent_Factor=5 Vertical_Extent_Factor=3 PEC_Launch_Width=0mm Reference_Net=VDD} Type="Pad Port" Pin=TXDATA3+_BGA_F1
  TXDATA3+_FCHIP_H1: Properties{Impedance=50ohm Magnitude=0V Phase=0deg Renormalize_Impedence=50ohm Deembed_Distance=0mm Layer_Alignment=Lower Horizontal_Extent_Factor=5 Vertical_Extent_Factor=3 PEC_Launch_Width=0mm Reference_Net=VDD} Type="Pad Port" Pin=TXDATA3+_FCHIP_H1
  TXDATA3-_BGA_G1: Properties{Impedance=50ohm Magnitude=0V Phase=0deg Renormalize_Impedence=50ohm Deembed_Distance=0mm Layer_Alignment=Upper Horizontal_Extent_Factor=5 Vertical_Extent_Factor=3 PEC_Launch_Width=0mm Reference_Net=VDD} Type="Pad Port" Pin=TXDATA3-_BGA_G1
  TXDATA3-_FCHIP_J1: Properties{Impedance=50ohm Magnitude=0V Phase=0deg Renormalize_Impedence=50ohm Deembed_Distance=0mm Layer_Alignment=Lower Horizontal_Extent_Factor=5 Vertical_Extent_Factor=3 PEC_Launch_Width=0mm Reference_Net=VDD} Type="Pad Port" Pin=TXDATA3-_FCHIP_J1
  TXDATA4+_BGA_H1: Properties{Impedance=50ohm Magnitude=0V Phase=0deg Renormalize_Impedence=50ohm Deembed_Distance=0mm Layer_Alignment=Upper Horizontal_Extent_Factor=5 Vertical_Extent_Factor=3 PEC_Launch_Width=0mm Reference_Net=VDD} Type="Pad Port" Pin=TXDATA4+_BGA_H1
  TXDATA4+_FCHIP_K1: Properties{Impedance=50ohm Magnitude=0V Phase=0deg Renormalize_Impedence=50ohm Deembed_Distance=0mm Layer_Alignment=Lower Horizontal_Extent_Factor=5 Vertical_Extent_Factor=3 PEC_Launch_Width=0mm Reference_Net=VDD} Type="Pad Port" Pin=TXDATA4+_FCHIP_K1
  TXDATA4-_BGA_J1: Properties{Impedance=50ohm Magnitude=0V Phase=0deg Renormalize_Impedence=50ohm Deembed_Distance=0mm Layer_Alignment=Upper Horizontal_Extent_Factor=5 Vertical_Extent_Factor=3 PEC_Launch_Width=0mm Reference_Net=VDD} Type="Pad Port" Pin=TXDATA4-_BGA_J1
  TXDATA4-_FCHIP_L1: Properties{Impedance=50ohm Magnitude=0V Phase=0deg Renormalize_Impedence=50ohm Deembed_Distance=0mm Layer_Alignment=Lower Horizontal_Extent_Factor=5 Vertical_Extent_Factor=3 PEC_Launch_Width=0mm Reference_Net=VDD} Type="Pad Port" Pin=TXDATA4-_FCHIP_L1
  TXDATA5+_BGA_K1: Properties{Impedance=50ohm Magnitude=0V Phase=0deg Renormalize_Impedence=50ohm Deembed_Distance=0mm Layer_Alignment=Upper Horizontal_Extent_Factor=5 Vertical_Extent_Factor=3 PEC_Launch_Width=0mm Reference_Net=VDD} Type="Pad Port" Pin=TXDATA5+_BGA_K1
  TXDATA5+_FCHIP_M1: Properties{Impedance=50ohm Magnitude=0V Phase=0deg Renormalize_Impedence=50ohm Deembed_Distance=0mm Layer_Alignment=Lower Horizontal_Extent_Factor=5 Vertical_Extent_Factor=3 PEC_Launch_Width=0mm Reference_Net=VDD} Type="Pad Port" Pin=TXDATA5+_FCHIP_M1
  TXDATA5-_BGA_L1: Properties{Impedance=50ohm Magnitude=0V Phase=0deg Renormalize_Impedence=50ohm Deembed_Distance=0mm Layer_Alignment=Upper Horizontal_Extent_Factor=5 Vertical_Extent_Factor=3 PEC_Launch_Width=0mm Reference_Net=VDD} Type="Pad Port" Pin=TXDATA5-_BGA_L1
  TXDATA5-_FCHIP_N1: Properties{Impedance=50ohm Magnitude=0V Phase=0deg Renormalize_Impedence=50ohm Deembed_Distance=0mm Layer_Alignment=Lower Horizontal_Extent_Factor=5 Vertical_Extent_Factor=3 PEC_Launch_Width=0mm Reference_Net=VDD} Type="Pad Port" Pin=TXDATA5-_FCHIP_N1
  TXDATA6+_BGA_J2: Properties{Impedance=50ohm Magnitude=0V Phase=0deg Renormalize_Impedence=50ohm Deembed_Distance=0mm Layer_Alignment=Upper Horizontal_Extent_Factor=5 Vertical_Extent_Factor=3 PEC_Launch_Width=0mm Reference_Net=VDD} Type="Pad Port" Pin=TXDATA6+_BGA_J2
  TXDATA6+_FCHIP_P1: Properties{Impedance=50ohm Magnitude=0V Phase=0deg Renormalize_Impedence=50ohm Deembed_Distance=0mm Layer_Alignment=Lower Horizontal_Extent_Factor=5 Vertical_Extent_Factor=3 PEC_Launch_Width=0mm Reference_Net=VDD} Type="Pad Port" Pin=TXDATA6+_FCHIP_P1
  TXDATA6-_BGA_K2: Properties{Impedance=50ohm Magnitude=0V Phase=0deg Renormalize_Impedence=50ohm Deembed_Distance=0mm Layer_Alignment=Upper Horizontal_Extent_Factor=5 Vertical_Extent_Factor=3 PEC_Launch_Width=0mm Reference_Net=VDD} Type="Pad Port" Pin=TXDATA6-_BGA_K2
  TXDATA6-_FCHIP_R1: Properties{Impedance=50ohm Magnitude=0V Phase=0deg Renormalize_Impedence=50ohm Deembed_Distance=0mm Layer_Alignment=Lower Horizontal_Extent_Factor=5 Vertical_Extent_Factor=3 PEC_Launch_Width=0mm Reference_Net=VDD} Type="Pad Port" Pin=TXDATA6-_FCHIP_R1
  TXDATA7+_BGA_L3: Properties{Impedance=50ohm Magnitude=0V Phase=0deg Renormalize_Impedence=50ohm Deembed_Distance=0mm Layer_Alignment=Upper Horizontal_Extent_Factor=5 Vertical_Extent_Factor=3 PEC_Launch_Width=0mm Reference_Net=VDD} Type="Pad Port" Pin=TXDATA7+_BGA_L3
  TXDATA7+_FCHIP_U1: Properties{Impedance=50ohm Magnitude=0V Phase=0deg Renormalize_Impedence=50ohm Deembed_Distance=0mm Layer_Alignment=Lower Horizontal_Extent_Factor=5 Vertical_Extent_Factor=3 PEC_Launch_Width=0mm Reference_Net=VDD} Type="Pad Port" Pin=TXDATA7+_FCHIP_U1
  TXDATA7-_BGA_L2: Properties{Impedance=50ohm Magnitude=0V Phase=0deg Renormalize_Impedence=50ohm Deembed_Distance=0mm Layer_Alignment=Upper Horizontal_Extent_Factor=5 Vertical_Extent_Factor=3 PEC_Launch_Width=0mm Reference_Net=VDD} Type="Pad Port" Pin=TXDATA7-_BGA_L2
  TXDATA7-_FCHIP_T1: Properties{Impedance=50ohm Magnitude=0V Phase=0deg Renormalize_Impedence=50ohm Deembed_Distance=0mm Layer_Alignment=Lower Horizontal_Extent_Factor=5 Vertical_Extent_Factor=3 PEC_Launch_Width=0mm Reference_Net=VDD} Type="Pad Port" Pin=TXDATA7-_FCHIP_T1
  VDD_10_BGA_F6: Properties{Impedance=50ohm Magnitude=0V Phase=0deg Renormalize_Impedence=50ohm Deembed_Distance=0mm Layer_Alignment=Upper Horizontal_Extent_Factor=5 Vertical_Extent_Factor=3 PEC_Launch_Width=0mm Reference_Net=VDD} Type="Pad Port" Pin=VDD_10_BGA_F6
  VDD_11_BGA_G6: Properties{Impedance=50ohm Magnitude=0V Phase=0deg Renormalize_Impedence=50ohm Deembed_Distance=0mm Layer_Alignment=Upper Horizontal_Extent_Factor=5 Vertical_Extent_Factor=3 PEC_Launch_Width=0mm Reference_Net=VDD} Type="Pad Port" Pin=VDD_11_BGA_G6
  VDD_12_BGA_H6: Properties{Impedance=50ohm Magnitude=0V Phase=0deg Renormalize_Impedence=50ohm Deembed_Distance=0mm Layer_Alignment=Upper Horizontal_Extent_Factor=5 Vertical_Extent_Factor=3 PEC_Launch_Width=0mm Reference_Net=VDD} Type="Pad Port" Pin=VDD_12_BGA_H6
  VDD_1_FCHIP_P15: Properties{Impedance=50ohm Magnitude=0V Phase=0deg Renormalize_Impedence=50ohm Deembed_Distance=0mm Layer_Alignment=Lower Horizontal_Extent_Factor=5 Vertical_Extent_Factor=3 PEC_Launch_Width=0mm Reference_Net=VDD} Type="Pad Port" Pin=VDD_1_FCHIP_P15
  VDD_2_FCHIP_E15: Properties{Impedance=50ohm Magnitude=0V Phase=0deg Renormalize_Impedence=50ohm Deembed_Distance=0mm Layer_Alignment=Lower Horizontal_Extent_Factor=5 Vertical_Extent_Factor=3 PEC_Launch_Width=0mm Reference_Net=VDD} Type="Pad Port" Pin=VDD_2_FCHIP_E15
  VDD_3_BGA_K9: Properties{Impedance=50ohm Magnitude=0V Phase=0deg Renormalize_Impedence=50ohm Deembed_Distance=0mm Layer_Alignment=Upper Horizontal_Extent_Factor=5 Vertical_Extent_Factor=3 PEC_Launch_Width=0mm Reference_Net=VDD} Type="Pad Port" Pin=VDD_3_BGA_K9
  VDD_4_BGA_K4: Properties{Impedance=50ohm Magnitude=0V Phase=0deg Renormalize_Impedence=50ohm Deembed_Distance=0mm Layer_Alignment=Upper Horizontal_Extent_Factor=5 Vertical_Extent_Factor=3 PEC_Launch_Width=0mm Reference_Net=VDD} Type="Pad Port" Pin=VDD_4_BGA_K4
  VDD_5_FCHIP_R15: Properties{Impedance=50ohm Magnitude=0V Phase=0deg Renormalize_Impedence=50ohm Deembed_Distance=0mm Layer_Alignment=Lower Horizontal_Extent_Factor=5 Vertical_Extent_Factor=3 PEC_Launch_Width=0mm Reference_Net=VDD} Type="Pad Port" Pin=VDD_5_FCHIP_R15
  VDD_6_FCHIP_D15: Properties{Impedance=50ohm Magnitude=0V Phase=0deg Renormalize_Impedence=50ohm Deembed_Distance=0mm Layer_Alignment=Lower Horizontal_Extent_Factor=5 Vertical_Extent_Factor=3 PEC_Launch_Width=0mm Reference_Net=VDD} Type="Pad Port" Pin=VDD_6_FCHIP_D15
  VDD_7_FCHIP_L15: Properties{Impedance=50ohm Magnitude=0V Phase=0deg Renormalize_Impedence=50ohm Deembed_Distance=0mm Layer_Alignment=Lower Horizontal_Extent_Factor=5 Vertical_Extent_Factor=3 PEC_Launch_Width=0mm Reference_Net=VDD} Type="Pad Port" Pin=VDD_7_FCHIP_L15
  VDD_8_FCHIP_H15: Properties{Impedance=50ohm Magnitude=0V Phase=0deg Renormalize_Impedence=50ohm Deembed_Distance=0mm Layer_Alignment=Lower Horizontal_Extent_Factor=5 Vertical_Extent_Factor=3 PEC_Launch_Width=0mm Reference_Net=VDD} Type="Pad Port" Pin=VDD_8_FCHIP_H15
  VDD_9_BGA_E6: Properties{Impedance=50ohm Magnitude=0V Phase=0deg Renormalize_Impedence=50ohm Deembed_Distance=0mm Layer_Alignment=Upper Horizontal_Extent_Factor=5 Vertical_Extent_Factor=3 PEC_Launch_Width=0mm Reference_Net=VDD} Type="Pad Port" Pin=VDD_9_BGA_E6
  VSS_1_BGA_E7: Properties{Impedance=50ohm Magnitude=0V Phase=0deg Renormalize_Impedence=50ohm Deembed_Distance=0mm Layer_Alignment=Upper Horizontal_Extent_Factor=5 Vertical_Extent_Factor=3 PEC_Launch_Width=0mm Reference_Net=VDD} Type="Pad Port" Pin=VSS_1_BGA_E7
  VSS_2_BGA_F5: Properties{Impedance=50ohm Magnitude=0V Phase=0deg Renormalize_Impedence=50ohm Deembed_Distance=0mm Layer_Alignment=Upper Horizontal_Extent_Factor=5 Vertical_Extent_Factor=3 PEC_Launch_Width=0mm Reference_Net=VDD} Type="Pad Port" Pin=VSS_2_BGA_F5
  VSS_3_BGA_F7: Properties{Impedance=50ohm Magnitude=0V Phase=0deg Renormalize_Impedence=50ohm Deembed_Distance=0mm Layer_Alignment=Upper Horizontal_Extent_Factor=5 Vertical_Extent_Factor=3 PEC_Launch_Width=0mm Reference_Net=VDD} Type="Pad Port" Pin=VSS_3_BGA_F7
  VSS_4_BGA_G5: Properties{Impedance=50ohm Magnitude=0V Phase=0deg Renormalize_Impedence=50ohm Deembed_Distance=0mm Layer_Alignment=Upper Horizontal_Extent_Factor=5 Vertical_Extent_Factor=3 PEC_Launch_Width=0mm Reference_Net=VDD} Type="Pad Port" Pin=VSS_4_BGA_G5
  VSS_5_BGA_G7: Properties{Impedance=50ohm Magnitude=0V Phase=0deg Renormalize_Impedence=50ohm Deembed_Distance=0mm Layer_Alignment=Upper Horizontal_Extent_Factor=5 Vertical_Extent_Factor=3 PEC_Launch_Width=0mm Reference_Net=VDD} Type="Pad Port" Pin=VSS_5_BGA_G7
  VSS_6_BGA_H5: Properties{Impedance=50ohm Magnitude=0V Phase=0deg Renormalize_Impedence=50ohm Deembed_Distance=0mm Layer_Alignment=Upper Horizontal_Extent_Factor=5 Vertical_Extent_Factor=3 PEC_Launch_Width=0mm Reference_Net=VDD} Type="Pad Port" Pin=VSS_6_BGA_H5
  VSS_7_BGA_H7: Properties{Impedance=50ohm Magnitude=0V Phase=0deg Renormalize_Impedence=50ohm Deembed_Distance=0mm Layer_Alignment=Upper Horizontal_Extent_Factor=5 Vertical_Extent_Factor=3 PEC_Launch_Width=0mm Reference_Net=VDD} Type="Pad Port" Pin=VSS_7_BGA_H7
setups:
  HFSS PI Setup 1: SolveSetupType=HFSSPI
    sweep HFSS PI Setup 1 _ HFSS PI S-parameter Sweep: DEC 1Hz 10MHz 20 LINC 10MHz 5GHz 500;
  SIwave SYZ 1: SolveSetupType=SIwave
    sweep SYZ Sweep 1: LINC 10MHz 5GHz 500;
