| u26a_800.ibs * IBIS 4.0 Model
| 256Mb DDR-2 SDRAM - Die Revision "B"
| Valid for DDR2-667 and DDR2-800 operation
|  Part Number   VDD/VDDQ   Architecture   Package
| MT47H64M4BP   1.8V/1.8V   64Meg x 4   60-Ball FBGA
| MT47H64M4BP_CLP   1.8V/1.8V   64Meg x 4   Common Landing Pattern
| MT47H32M8BP   1.8V/1.8V   32Meg x 8   60-Ball FBGA
| MT47H32M8BP_CLP   1.8V/1.8V   32Meg x 8   Common Landing Pattern
| MT47H16M16BG   1.8V/1.8V   16Meg x 16   84-Ball FBGA
| MT47H16M16BG_CLP   1.8V/1.8V   16Meg x 16   Common Landing Pattern
[IBIS Ver]   4.0
[File name]   u26a_800.ibs
[Date]   05/03/2007
[File Rev]   2.4
[Source]   From silicon level SPICE model at Micron Technology, Inc.
   Micron Technology, Inc.
   8000 S. Federal Way
   P.O. Box 6, M/S: 01-711
   Boise, ID 83707-0006
[Notes]   Revision History:
   Rev 2.0: 8/07/2003
   - includes complete package parasitics
   - all models match latest silicon measurements
   - both datasheet ballout and common landing pattern
   ballouts included
   Rev 2.1: 05/17/2005
   - updated package code from "FP/FG" to "BP/BG"
   - [Model Spec] and [Receiver Thresholds] parameters added
   - [IBIS Ver] changed to 4.0
   - Added Reduced-Drive strength DQ model (DQ_HALF)
   - DQ, RDQS, DM, and ODT models updated to match latest
   circuit changes to reduce C_comp and add 50 ohm ODT
   - Updated DQ and RDQS models reflect new drive strength
   trimming (less min/max I-V curve variation)
   - All models created from parasitic netlists to better
   match real silicon
   - Typical temperature changed from 25C to 40C
   - All models updated with Typical transistor model corner
   in slow case for DDR2-667 compatibility
   - Vinh, Vinl updated for DDR2-667 spec. levels
   Rev 2.2: 11/02/2005
   - All ODT models included within one IBIS file
   - ODT modeled with [Submodel]
   - Minimum temperature changed from 85C to 100C
   Rev 2.3: 03/23/2006
   - Removed Overshoot/Undershoot parameters
   - Added new [Receiver Thresholds] parameters
   Rev 2.4: 05/03/2007
   - Updated all HALF strength models to reflect proper
   drive strength trimming in min and max corners
   - Updated all models to better match SPICE model
   IBIS Quality Notes
|IQ SUMMARY Overall Quality of component and models Level 2b
|IQ Level 0 - 0 errors 9 warnings
|IQ Level 1 - All checks done for completeness and correctness
|IQ Level 2 - HSPICE Correlation
|IQ Buffer DQ_FULL_800/DQ_FULL_ODT50_800:   Quality level 2b
|IQ Buffer DQ_FULL_ODT75_800/DQ_FULL_ODT150_800: Quality level 2b
|IQ Buffer DQ_HALF_800/DQ_HALF_ODT50_800:   Quality level 2b
|IQ Buffer DQ_FULL_ODT75_800/DQ_FULL_ODT150_800: Quality level 2b
|IQ Buffer RDQS_FULL_800/RDQS_HALF_800:   Quality level 2b
|IQ Buffer DM_IN_800/DM_ODT50_800:   Quality level 2b
|IQ Buffer DM_ODT75_800/DM_ODT150_800:   Quality level 2b
|IQ Level 0
|   All Submodels: When running through ibischk4.0, this file
|   contains 9 warnings about pullup and pulldown being non-monotonic.
|   When [Submodel] I-V curves are added to original [Power Clamp] and
|   [Gnd Clamp] curves, the resultant curve is monotonic.  This is not
|   checked correctly with the IBIS parser.
|IQ WARNING (line 11678) - GND Clamp Typical data is non-monotonic
|IQ WARNING (line 11683) - GND Clamp Minimum data is non-monotonic
|IQ WARNING (line 11683) - GND Clamp Maximum data is non-monotonic
|IQ WARNING (line 11809) - GND Clamp Typical data is non-monotonic
|IQ WARNING (line 11813) - GND Clamp Minimum data is non-monotonic
|IQ WARNING (line 11813) - GND Clamp Maximum data is non-monotonic
|IQ WARNING (line 11937) - GND Clamp Typical data is non-monotonic
|IQ WARNING (line 11941) - GND Clamp Maximum data is non-monotonic
|IQ WARNING (line 11942) - GND Clamp Minimum data is non-monotonic
|IQ Level 1
|   All Level 1 checks performed and are either OK or NA
|IQ Level 2
|   Using VT IBIS Data compared to source hspice models
|IQ Level 2b
|   C_comp laboratory and hspice correlation
|IQ BEGIN IBIS Quality Checklist
|IQ FILE: u26a_800.ibs   IQ Level:   1
|IQ COMPONENT: MT47H64M4BP-3_25   IQ Level:   1
|IQ COMPONENT: MT47H64M4BP_CLP-3_25   IQ Level:   1
|IQ COMPONENT: MT47H32M8BP-3_25   IQ Level:   1
|IQ COMPONENT: MT47H32M8BP_CLP-3_25   IQ Level:   1
|IQ COMPONENT: MT47H16M16BG-3_25   IQ Level:   1
|IQ COMPONENT: MT47H16M16BG_CLP-3_25  IQ Level:   1
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[Disclaimer]  This software code and all associated documentation, comments
              or other information (collectively "Software") is provided
              "AS IS" without warranty of any kind. MICRON TECHNOLOGY, INC.
              ("MTI") EXPRESSLY DISCLAIMS ALL WARRANTIES EXPRESS OR IMPLIED,
              INCLUDING BUT NOT LIMITED TO, NONINFRINGEMENT OF THIRD PARTY
              RIGHTS, AND ANY IMPLIED WARRANTIES OF MERCHANTABILITY OR
              FITNESS FOR ANY PARTICULAR PURPOSE. MTI DOES NOT WARRANT THAT
              THE SOFTWARE WILL MEET YOUR REQUIREMENTS, OR THAT THE
              OPERATION OF THE SOFTWARE WILL BE UNINTERRUPTED OR ERROR-FREE.
              FURTHERMORE, MTI DOES NOT MAKE ANY REPRESENTATIONS REGARDING
              THE USE OR THE RESULTS OF THE USE OF THE SOFTWARE IN TERMS OF
              ITS CORRECTNESS, ACCURACY, RELIABILITY, OR OTHERWISE. THE
              ENTIRE RISK ARISING OUT OF USE OR PERFORMANCE OF THE SOFTWARE
              REMAINS WITH YOU. IN NO EVENT SHALL MTI, ITS AFFILIATED
              COMPANIES OR THEIR SUPPLIERS BE LIABLE FOR ANY DIRECT,
              INDIRECT, CONSEQUENTIAL, INCIDENTAL, OR SPECIAL DAMAGES
              (INCLUDING, WITHOUT LIMITATION, DAMAGES FOR LOSS OF PROFITS,
              BUSINESS INTERRUPTION, OR LOSS OF INFORMATION) ARISING OUT OF
              YOUR USE OF OR INABILITY TO USE THE SOFTWARE, EVEN IF MTI HAS
              BEEN ADVISED OF THE POSSIBILITY OF SUCH DAMAGES. Because some
              jurisdictions prohibit the exclusion or limitation of
              liability for consequential or incidental damages, the above
              limitation may not apply to you.
[Copyright]   Copyright 2005 Micron Technology, Inc. All rights reserved.
|   COMPONENT: MT47H64M4BP-3_25
[Component]   MT47H64M4BP-3_25
[Manufacturer]  Micron Technology, Inc.
[Package]   | 8mm x 12mm FBGA
|variable   typ   min   max
R_pkg   70.0m   57.0m   92.3m
L_pkg   2.21nH   1.46nH   3.32nH
C_pkg   0.30pF   0.25pF   0.39pF
[Pin]  signal_name   model_name   R_pin   L_pin   C_pin
A1   VDD   POWER   44.3m   1.99nH   0.59pF
A2   NC   NC   NA   NA   NA
A3   VSS   GND   30.9m   1.00nH   0.43pF
A7   VSSQ   GND   61.4m   2.01nH   0.37pF
A8   DQS#   DQS#   79.7m   2.84nH   0.37pF
A9   VDDQ   POWER   92.9m   3.63nH   0.42pF
B1   NF   NF_IN_800   93.6m   3.62nH   0.42pF
B2   VSSQ   GND   77.3m   2.73nH   0.42pF
B3   DM   DM   62.6m   1.97nH   0.29pF
B7   DQS   DQ   63.0m   1.89nH   0.29pF
B8   VSSQ   GND   78.3m   2.66nH   0.42pF
B9   NF   NF_IN_800   93.4m   3.54nH   0.41pF
C1   VDDQ   POWER   101.1m  3.95nH   0.47pF
C2   DQ1   DQ   77.6m   2.65nH   0.35pF
C3   VDDQ   POWER   63.5m   2.00nH   0.45pF
C7   VDDQ   POWER   62.2m   1.88nH   0.42pF
C8   DQ0   DQ   77.9m   2.71nH   0.35pF
C9   VDDQ   POWER   90.8m   3.56nH   0.42pF
D1   NF   NF_IN_800   95.3m   3.64nH   0.43pF
D2   VSSQ   GND   81.3m   2.65nH   0.50pF
D3   DQ3   DQ   62.2m   1.91nH   0.29pF
D7   DQ2   DQ   62.6m   1.94nH   0.29pF
D8   VSSQ   GND   77.2m   2.72nH   0.42pF
D9   NF   NF_IN_800   92.0m   3.47nH   0.41pF
E1   VDDL   POWER   89.4m   3.43nH   0.39pF
E2   VREF   POWER   75.8m   2.60nH   0.42pF
E3   VSS   GND   61.6m   1.82nH   0.29pF
E7   VSSDL   GND   61.4m   1.89nH   0.41pF
E8   CK   CLKIN_800   77.4m   2.69nH   0.35pF
E9   VDD   POWER   99.9m   3.76nH   0.44pF
F2   CKE   IN_800   78.2m   2.84nH   0.33pF
F3   WE#   IN_800   62.6m   1.98nH   0.28pF
F7   RAS#   IN_800   61.3m   1.72nH   0.28pF
F8   CK#   CLKIN_800   80.8m   2.55nH   0.36pF
F9   ODT   IN_800   92.3m   3.32nH   0.39pF
G1   RFU   NC   NA   NA   NA
G2   BA0   IN_800   81.5m   2.67nH   0.36pF
G3   BA1   IN_800   64.7m   1.97nH   0.29pF
G7   CAS#   IN_800   59.7m   1.63nH   0.27pF
G8   CS#   IN_800   75.1m   2.38nH   0.32pF
H2   A10   IN_800   78.2m   2.60nH   0.32pF
H3   A1   IN_800   63.7m   1.80nH   0.28pF
H7   A2   IN_800   61.2m   1.80nH   0.27pF
H8   A0   IN_800   77.4m   2.59nH   0.32pF
H9   VDD   POWER   88.2m   3.36nH   0.36pF
J1   VSS   GND   103.4m  3.77nH   0.42pF
J2   A3   IN_800   75.0m   2.42nH   0.30pF
J3   A5   IN_800   59.5m   1.65nH   0.26pF
J7   A6   IN_800   60.0m   1.66nH   0.26pF
J8   A4   IN_800   73.7m   2.40nH   0.30pF
K2   A7   IN_800   72.1m   2.26nH   0.29pF
K3   A9   IN_800   58.5m   1.50nH   0.25pF
K7   A11   IN_800   57.0m   1.46nH   0.25pF
K8   A8   IN_800   74.4m   2.28nH   0.29pF
K9   VSS   GND   92.7m   3.25nH   0.33pF
L1   VDD   POWER   84.0m   3.08nH   0.31pF
L2   A12   IN_800   70.2m   2.18nH   0.30pF
L3   RFU   NC   NA   NA   NA
L7   RFU   NC   NA   NA   NA
L8   RFU   NC   NA   NA   NA
|**********************DIFF PIN*********************************************
[Diff_pin]   inv_pin   vdiff   tdelay_typ   tdelay_min   tdelay_max
   E8   F8   .250V   0ns   NA   NA
   B7   A8   .250V   0ns   NA   NA
|  Pins B7 and A8 are a differential I/O only when DQS# is enabled via MRS
|  If DQS# is disabled, then B7 (DQS) is a single ended I/O and A8 is a NC
|   COMPONENT: MT47H64M4BP_CLP-3_25
[Component]   MT47H64M4BP_CLP-3_25
[Manufacturer]  Micron Technology, Inc.
[Package]   | 8mm x 12mm FBGA with Common Landing Pattern Ballout
|variable   typ   min   max
R_pkg   70.0m   57.0m   92.3m
L_pkg   2.21nH   1.46nH   3.32nH
C_pkg   0.30pF   0.25pF   0.39pF
[Pin]   signal_name  model_name   R_pin   L_pin   C_pin
H1   VDD   POWER   44.3m   1.99nH   0.59pF
H2   NC   NC   NA   NA   NA
H3   VSS   GND   30.9m   1.00nH   0.43pF
H7   VSSQ   GND   61.4m   2.01nH   0.37pF
H8   DQS#   DQS#   79.7m   2.84nH   0.37pF
H9   VDDQ   POWER   92.9m   3.63nH   0.42pF
J1   NF   NF_IN_800   93.6m   3.62nH   0.42pF
J2   VSSQ   GND   77.3m   2.73nH   0.42pF
J3   DM   DM   62.6m   1.97nH   0.29pF
J7   DQS   DQ   63.0m   1.89nH   0.29pF
J8   VSSQ   GND   78.3m   2.66nH   0.42pF
J9   NF   NF_IN_800   93.4m   3.54nH   0.41pF
K1   VDDQ   POWER   101.1m  3.95nH   0.47pF
K2   DQ1   DQ   77.6m   2.65nH   0.35pF
K3   VDDQ   POWER   63.5m   2.00nH   0.45pF
K7   VDDQ   POWER   62.2m   1.88nH   0.42pF
K8   DQ0   DQ   77.9m   2.71nH   0.35pF
K9   VDDQ   POWER   90.8m   3.56nH   0.42pF
L1   NF   NF_IN_800   95.3m   3.64nH   0.43pF
L2   VSSQ   GND   81.3m   2.65nH   0.50pF
L3   DQ3   DQ   62.2m   1.91nH   0.29pF
L7   DQ2   DQ   62.6m   1.94nH   0.29pF
L8   VSSQ   GND   77.2m   2.72nH   0.42pF
L9   NF   NF_IN_800   92.0m   3.47nH   0.41pF
M1   VDDL   POWER   89.4m   3.43nH   0.39pF
M2   VREF   POWER   75.8m   2.60nH   0.42pF
M3   VSS   GND   61.6m   1.82nH   0.29pF
M7   VSSDL   GND   61.4m   1.89nH   0.41pF
M8   CK   CLKIN_800   77.4m   2.69nH   0.35pF
M9   VDD   POWER   99.9m   3.76nH   0.44pF
N2   CKE   IN_800   78.2m   2.84nH   0.33pF
N3   WE#   IN_800   62.6m   1.98nH   0.28pF
N7   RAS#   IN_800   61.3m   1.72nH   0.28pF
N8   CK#   CLKIN_800   80.8m   2.55nH   0.36pF
N9   ODT   IN_800   92.3m   3.32nH   0.39pF
P1   RFU   NC   NA   NA   NA
P2   BA0   IN_800   81.5m   2.67nH   0.36pF
P3   BA1   IN_800   64.7m   1.97nH   0.29pF
P7   CAS#   IN_800   59.7m   1.63nH   0.27pF
P8   CS#   IN_800   75.1m   2.38nH   0.32pF
R2   A10   IN_800   78.2m   2.60nH   0.32pF
R3   A1   IN_800   63.7m   1.80nH   0.28pF
R7   A2   IN_800   61.2m   1.80nH   0.27pF
R8   A0   IN_800   77.4m   2.59nH   0.32pF
R9   VDD   POWER   88.2m   3.36nH   0.36pF
T1   VSS   GND   103.4m  3.77nH   0.42pF
T2   A3   IN_800   75.0m   2.42nH   0.30pF
T3   A5   IN_800   59.5m   1.65nH   0.26pF
T7   A6   IN_800   60.0m   1.66nH   0.26pF
T8   A4   IN_800   73.7m   2.40nH   0.30pF
U2   A7   IN_800   72.1m   2.26nH   0.29pF
U3   A9   IN_800   58.5m   1.50nH   0.25pF
U7   A11   IN_800   57.0m   1.46nH   0.25pF
U8   A8   IN_800   74.4m   2.28nH   0.29pF
U9   VSS   GND   92.7m   3.25nH   0.33pF
V1   VDD   POWER   84.0m   3.08nH   0.31pF
V2   A12   IN_800   70.2m   2.18nH   0.30pF
V3   RFU   NC   NA   NA   NA
V7   RFU   NC   NA   NA   NA
V8   RFU   NC   NA   NA   NA
|**********************DIFF PIN*********************************************
[Diff_pin]   inv_pin   vdiff   tdelay_typ   tdelay_min   tdelay_max
   M8   N8   .250V   0ns   NA   NA
   J7   H8   .250V   0ns   NA   NA
|  Pins J7 and H8 are a differential I/O only when DQS# is enabled via MRS
|  If DQS# is disabled, then J7 (DQS) is a single ended I/O and H8 is a NC
|   COMPONENT: MT47H32M8BP-3_25
[Component]   MT47H32M8BP-3_25
[Manufacturer]  Micron Technology, Inc.
[Package]   | 8mm x 12mm FBGA
|variable   typ   min   max
R_pkg   71.9m   57.0m   95.3m
L_pkg   2.36nH   1.46nH   3.64nH
C_pkg   0.32pF   0.25pF   0.43pF
[Pin]  signal_name   model_name   R_pin   L_pin   C_pin
A1   VDD   POWER   44.3m   1.99nH   0.59pF
A2   NU,RDQS#   RDQS#   76.8m   2.69nH   0.35pF
A3   VSS   GND   30.9m   1.00nH   0.43pF
A7   VSSQ   GND   61.4m   2.01nH   0.37pF
A8   DQS#   DQS#   79.7m   2.84nH   0.37pF
A9   VDDQ   POWER   92.9m   3.63nH   0.42pF
B1   DQ6   DQ   93.6m   3.62nH   0.42pF
B2   VSSQ   GND   77.3m   2.73nH   0.42pF
B3   DM,RDQS   DM_RDQS   62.6m   1.97nH   0.29pF
B7   DQS   DQ   63.0m   1.89nH   0.29pF
B8   VSSQ   GND   78.3m   2.66nH   0.42pF
B9   DQ7   DQ   93.4m   3.54nH   0.41pF
C1   VDDQ   POWER   101.1m   3.95nH   0.47pF
C2   DQ1   DQ   77.6m   2.65nH   0.35pF
C3   VDDQ   POWER   63.5m   2.00nH   0.45pF
C7   VDDQ   POWER   62.2m   1.88nH   0.42pF
C8   DQ0   DQ   77.9m   2.71nH   0.35pF
C9   VDDQ   POWER   90.8m   3.56nH   0.42pF
D1   DQ4   DQ   95.3m   3.64nH   0.43pF
D2   VSSQ   GND   81.3m   2.65nH   0.50pF
D3   DQ3   DQ   62.2m   1.91nH   0.29pF
D7   DQ2   DQ   62.6m   1.94nH   0.29pF
D8   VSSQ   GND   77.2m   2.72nH   0.42pF
D9   DQ5   DQ   92.0m   3.47nH   0.41pF
E1   VDDL   POWER   89.4m   3.43nH   0.39pF
E2   VREF   POWER   75.8m   2.60nH   0.42pF
E3   VSS   GND   61.6m   1.82nH   0.29pF
E7   VSSDL   GND   61.4m   1.89nH   0.41pF
E8   CK   CLKIN_800   77.4m   2.69nH   0.35pF
E9   VDD   POWER   99.9m   3.76nH   0.44pF
F2   CKE   IN_800   78.2m   2.84nH   0.33pF
F3   WE#   IN_800   62.6m   1.98nH   0.28pF
F7   RAS#   IN_800   61.3m   1.72nH   0.28pF
F8   CK#   CLKIN_800   80.8m   2.55nH   0.36pF
F9   ODT   IN_800   92.3m   3.32nH   0.39pF
G1   RFU   NC   NA   NA   NA
G2   BA0   IN_800   81.5m   2.67nH   0.36pF
G3   BA1   IN_800   64.7m   1.97nH   0.29pF
G7   CAS#   IN_800   59.7m   1.63nH   0.27pF
G8   CS#   IN_800   75.1m   2.38nH   0.32pF
H2   A10   IN_800   78.2m   2.60nH   0.32pF
H3   A1   IN_800   63.7m   1.80nH   0.28pF
H7   A2   IN_800   61.2m   1.80nH   0.27pF
H8   A0   IN_800   77.4m   2.59nH   0.32pF
H9   VDD   POWER   88.2m   3.36nH   0.36pF
J1   VSS   GND   103.4m   3.77nH   0.42pF
J2   A3   IN_800   75.0m   2.42nH   0.30pF
J3   A5   IN_800   59.5m   1.65nH   0.26pF
J7   A6   IN_800   60.0m   1.66nH   0.26pF
J8   A4   IN_800   73.7m   2.40nH   0.30pF
K2   A7   IN_800   72.1m   2.26nH   0.29pF
K3   A9   IN_800   58.5m   1.50nH   0.25pF
K7   A11   IN_800   57.0m   1.46nH   0.25pF
K8   A8   IN_800   74.4m   2.28nH   0.29pF
K9   VSS   GND   92.7m   3.25nH   0.33pF
L1   VDD   POWER   84.0m   3.08nH   0.31pF
L2   A12   IN_800   70.2m   2.18nH   0.30pF
L3   RFU   NC   NA   NA   NA
L7   RFU   NC   NA   NA   NA
L8   RFU   NC   NA   NA   NA
|**********************DIFF PIN*********************************************
[Diff_pin]   inv_pin   vdiff   tdelay_typ   tdelay_min   tdelay_max
   E8   F8   .250V   0ns   NA   NA
   B7   A8   .250V   0ns   NA   NA
|  Pins B7 and A8 are a differential I/O only when DQS# is enabled via MRS
|  If DQS# is disabled, then B7 (DQS) is a single ended I/O and A8 is a NC
|   B3   A2   .250V   0ns   NA   NA
|  Pins B3 and A2 (RDQS,RDQS#) are a differential output only if RDQS and
|  Differential Stobe MRS options are enabled
|   COMPONENT: MT47H32M8BP_CLP-3_25
[Component]   MT47H32M8BP_CLP-3_25
[Manufacturer]  Micron Technology, Inc.
[Package]   | 8mm x 12mm FBGA with Common Landing Pattern Ballout
|variable   typ   min   max
R_pkg   71.9m   57.0m   95.3m
L_pkg   2.36nH   1.46nH   3.64nH
C_pkg   0.32pF   0.25pF   0.43pF
[Pin]   signal_name  model_name   R_pin   L_pin   C_pin
H1   VDD   POWER   44.3m   1.99nH   0.59pF
H2   NU,RDQS#   RDQS#   76.8m   2.69nH   0.35pF
H3   VSS   GND   30.9m   1.00nH   0.43pF
H7   VSSQ   GND   61.4m   2.01nH   0.37pF
H8   DQS#   DQS#   79.7m   2.84nH   0.37pF
H9   VDDQ   POWER   92.9m   3.63nH   0.42pF
J1   DQ6   DQ   93.6m   3.62nH   0.42pF
J2   VSSQ   GND   77.3m   2.73nH   0.42pF
J3   DM,RDQS   DM_RDQS   62.6m   1.97nH   0.29pF
J7   DQS   DQ   63.0m   1.89nH   0.29pF
J8   VSSQ   GND   78.3m   2.66nH   0.42pF
J9   DQ7   DQ   93.4m   3.54nH   0.41pF
K1   VDDQ   POWER   101.1m   3.95nH   0.47pF
K2   DQ1   DQ   77.6m   2.65nH   0.35pF
K3   VDDQ   POWER   63.5m   2.00nH   0.45pF
K7   VDDQ   POWER   62.2m   1.88nH   0.42pF
K8   DQ0   DQ   77.9m   2.71nH   0.35pF
K9   VDDQ   POWER   90.8m   3.56nH   0.42pF
L1   DQ4   DQ   95.3m   3.64nH   0.43pF
L2   VSSQ   GND   81.3m   2.65nH   0.50pF
L3   DQ3   DQ   62.2m   1.91nH   0.29pF
L7   DQ2   DQ   62.6m   1.94nH   0.29pF
L8   VSSQ   GND   77.2m   2.72nH   0.42pF
L9   DQ5   DQ   92.0m   3.47nH   0.41pF
M1   VDDL   POWER   89.4m   3.43nH   0.39pF
M2   VREF   POWER   75.8m   2.60nH   0.42pF
M3   VSS   GND   61.6m   1.82nH   0.29pF
M7   VSSDL   GND   61.4m   1.89nH   0.41pF
M8   CK   CLKIN_800   77.4m   2.69nH   0.35pF
M9   VDD   POWER   99.9m   3.76nH   0.44pF
N2   CKE   IN_800   78.2m   2.84nH   0.33pF
N3   WE#   IN_800   62.6m   1.98nH   0.28pF
N7   RAS#   IN_800   61.3m   1.72nH   0.28pF
N8   CK#   CLKIN_800   80.8m   2.55nH   0.36pF
N9   ODT   IN_800   92.3m   3.32nH   0.39pF
P1   RFU   NC   NA   NA   NA
P2   BA0   IN_800   81.5m   2.67nH   0.36pF
P3   BA1   IN_800   64.7m   1.97nH   0.29pF
P7   CAS#   IN_800   59.7m   1.63nH   0.27pF
P8   CS#   IN_800   75.1m   2.38nH   0.32pF
R2   A10   IN_800   78.2m   2.60nH   0.32pF
R3   A1   IN_800   63.7m   1.80nH   0.28pF
R7   A2   IN_800   61.2m   1.80nH   0.27pF
R8   A0   IN_800   77.4m   2.59nH   0.32pF
R9   VDD   POWER   88.2m   3.36nH   0.36pF
T1   VSS   GND   103.4m   3.77nH   0.42pF
T2   A3   IN_800   75.0m   2.42nH   0.30pF
T3   A5   IN_800   59.5m   1.65nH   0.26pF
T7   A6   IN_800   60.0m   1.66nH   0.26pF
T8   A4   IN_800   73.7m   2.40nH   0.30pF
U2   A7   IN_800   72.1m   2.26nH   0.29pF
U3   A9   IN_800   58.5m   1.50nH   0.25pF
U7   A11   IN_800   57.0m   1.46nH   0.25pF
U8   A8   IN_800   74.4m   2.28nH   0.29pF
U9   VSS   GND   92.7m   3.25nH   0.33pF
V1   VDD   POWER   84.0m   3.08nH   0.31pF
V2   A12   IN_800   70.2m   2.18nH   0.30pF
V3   RFU   NC   NA   NA   NA
V7   RFU   NC   NA   NA   NA
V8   RFU   NC   NA   NA   NA
|**********************DIFF PIN*********************************************
[Diff_pin]   inv_pin   vdiff   tdelay_typ   tdelay_min   tdelay_max
   M8   N8   .250V   0ns   NA   NA
   J7   H8   .250V   0ns   NA   NA
|  Pins J7 and H8 are a differential I/O only when DQS# is enabled via MRS
|  If DQS# is disabled, then J7 (DQS) is a single ended I/O and H8 is a NC
|   J3   H2   .250V   0ns   NA   NA
|  Pins J3 and H2 (RDQS,RDQS#) are a differential output only if RDQS and
|  Differential Stobe MRS options are enabled
|   Model Selector
[Model Selector] RDQS#
NF_IN_800   Not Used if either RDQS or Diff. Strobe are disabled
RDQS_FULL_800   Full-Strength Output Driver
RDQS_HALF_800   Reduced-Strength Output Driver
[Model Selector] DM_RDQS
DM_IN_800   DM_IN_800 input model
DM_ODT50_800   DM Input model with 50 Ohm ODT Submodel
DM_ODT75_800   DM Input model with 75 Ohm ODT Submodel
DM_ODT150_800   DM Input model with 150 Ohm ODT Submodel
RDQS_FULL_800   Full-Strength Output Driver if RDQS is enabled with no ODT
RDQS_HALF_800   Reduced-Strength Output Driver if RDQS is enabled with no ODT
|   COMPONENT: MT47H16M16BG-3_25
[Component]   MT47H16M16BG-3_25
[Manufacturer]  Micron Technology, Inc.
[Package]   | 8mm x 14mm FBGA
|variable   typ   min   max
R_pkg   56.5m   43.2m   73.1m
L_pkg   1.96nH   1.24nH   2.97nH
C_pkg   0.27pF   0.19pF   0.37pF
[Pin]  signal_name   model_name   R_pin   L_pin   C_pin
A1   VDD   POWER   68.3m   3.11nH   0.27pF
A2   NC   NC   NA   NA   NA
A3   VSS   GND   49.8m   1.57nH   0.35pF
A7   VSSQ   GND   49.2m   1.56nH   0.28pF
A8   NU,UDQS#   DQS#   62.1m   2.29nH   0.31pF
A9   VDDQ   POWER   73.4m   3.05nH   0.38pF
B1   DQ14   DQ   69.0m   2.90nH   0.36pF
B2   VSSQ   GND   57.2m   2.10nH   0.30pF
B3   UDM   DM   44.8m   1.38nH   0.22pF
B7   UDQS   DQ   50.5m   1.47nH   0.25pF
B8   VSSQ   GND   61.2m   2.18nH   0.37pF
B9   DQ15   DQ   73.1m   2.97nH   0.37pF
C1   VDDQ   POWER   68.3m   2.84nH   0.35pF
C2   DQ9   DQ   56.9m   2.03nH   0.28pF
C3   VDDQ   POWER   44.9m   1.33nH   0.35pF
C7   VDDQ   POWER   49.3m   1.40nH   0.37pF
C8   DQ8   DQ   61.1m   2.16nH   0.30pF
C9   VDDQ   POWER   71.9m   2.94nH   0.36pF
D1   DQ12   DQ   68.8m   2.86nH   0.36pF
D2   VSSQ   GND   57.2m   2.05nH   0.36pF
D3   DQ11   DQ   45.6m   1.29nH   0.22pF
D7   DQ10   DQ   49.0m   1.40nH   0.23pF
D8   VSSQ   GND   60.0m   2.10nH   0.36pF
D9   DQ13   DQ   71.5m   2.95nH   0.35pF
E1   VDD   POWER   68.2m   2.81nH   0.35pF
E2   NC   NC   NA   NA   NA
E3   VSS   GND   45.1m   1.28nH   0.35pF
E7   VSSQ   GND   48.4m   1.42nH   0.36pF
E8   NU,LDQS#   DQS#   60.8m   2.18nH   0.30pF
E9   VDDQ   POWER   71.6m   2.96nH   0.36pF
F1   DQ6   DQ   68.0m   2.78nH   0.35pF
F2   VSSQ   GND   56.2m   2.00nH   0.35pF
F3   LDM   DM   44.7m   1.27nH   0.21pF
F7   LDQS   DQ   48.9m   1.37nH   0.22pF
F8   VSSQ   GND   60.3m   2.10nH   0.37pF
F9   DQ7   DQ   72.0m   2.89nH   0.35pF
G1   VDDQ   POWER   55.9m   1.98nH   0.36pF
G2   DQ1   DQ   56.9m   2.00nH   0.29pF
G3   VDDQ   POWER   44.6m   1.25nH   0.35pF
G7   VDDQ   POWER   48.3m   1.35nH   0.35pF
G8   DQ0   DQ   60.4m   2.09nH   0.30pF
G9   VDDQ   POWER   71.4m   2.91nH   0.36pF
H1   DQ4   DQ   67.7m   2.75nH   0.35pF
H2   VSSQ   GND   67.4m   2.77nH   0.35pF
H3   DQ3   DQ   44.5m   1.24nH   0.21pF
H7   DQ2   DQ   48.0m   1.38nH   0.22pF
H8   VSSQ   GND   59.9m   2.09nH   0.37pF
H9   DQ5   DQ   71.6m   2.86nH   0.36pF
J1   VDDL   POWER   66.2m   2.76nH   0.33pF
J2   VREF   POWER   55.9m   1.96nH   0.37pF
J3   VSS   GND   43.8m   1.23nH   0.37pF
J7   VSSDL   GND   48.0m   1.35nH   0.36pF
J8   CK   CLKIN_800   60.6m   2.10nH   0.29pF
J9   VDD   POWER   80.1m   3.25nH   0.41pF
K2   CKE   IN_800   53.8m   2.05nH   0.23pF
K3   WE#   IN_800   43.2m   1.24nH   0.19pF
K7   RAS#   IN_800   48.4m   1.33nH   0.22pF
K8   CK#   CLKIN_800   59.9m   2.07nH   0.29pF
K9   ODT   IN_800   72.1m   2.91nH   0.37pF
L1   RFU   NC   NA   NA   NA
L2   BA0   IN_800   53.9m   1.98nH   0.24pF
L3   BA1   IN_800   43.2m   1.26nH   0.19pF
L7   CAS#   IN_800   47.6m   1.38nH   0.21pF
L8   CS#   IN_800   59.9m   2.15nH   0.34pF
M2   A10   IN_800   55.9m   2.04nH   0.25pF
M3   A1   IN_800   43.2m   1.24nH   0.19pF
M7   A2   IN_800   47.2m   1.33nH   0.21pF
M8   A0   IN_800   58.9m   2.08nH   0.26pF
M9   VDD   POWER   70.4m   2.91nH   0.32pF
N1   VSS   GND   9.9m   0.47nH   0.07pF
N2   A3   IN_800   57.7m   2.10nH   0.27pF
N3   A5   IN_800   45.6m   1.32nH   0.21pF
N7   A6   IN_800   49.1m   1.40nH   0.23pF
N8   A4   IN_800   60.9m   2.12nH   0.28pF
P2   A7   IN_800   60.5m   2.15nH   0.32pF
P3   A9   IN_800   48.5m   1.43nH   0.25pF
P7   A11   IN_800   52.4m   1.58nH   0.25pF
P8   A8   IN_800   63.6m   2.30nH   0.32pF
P9   VSS   GND   71.2m   3.01nH   0.29pF
R1   VDD   POWER   71.4m   3.28nH   0.27pF
R2   A12   IN_800   58.8m   2.21nH   0.28pF
R3   RFU   NC   NA   NA   NA
R7   RFU   NC   NA   NA   NA
R8   RFU   NC   NA   NA   NA
|**********************DIFF PIN*********************************************
[Diff_pin]   inv_pin   vdiff   tdelay_typ   tdelay_min   tdelay_max
   J8   K8   .250V   0ns   NA   NA
   B7   A8   .250V   0ns   NA   NA
|  Pins B7 and A8 are a differential I/O only when DQS# is enabled via MRS
|  If DQS# is disabled, then B7(UDQS) is a single ended I/O and A8 is a NC
   F7   E8   .250V   0ns   NA   NA
|  Pins F7 and E8 are a differential I/O only when DQS# is enabled via MRS
|  If DQS# is disabled, then F7(LDQS) is a single ended I/O and E8 is a NC
|   COMPONENT: MT47H16M16BG_CLP-3_25
[Component]   MT47H16M16BG_CLP-3_25
[Manufacturer]  Micron Technology, Inc.
[Package]   | 8mm x 14mm FBGA with Common Landing Pattern Ballout
|variable   typ   min   max
R_pkg   56.5m   43.2m   73.1m
L_pkg   1.96nH   1.24nH   2.97nH
C_pkg   0.27pF   0.19pF   0.37pF
[Pin]  signal_name   model_name   R_pin   L_pin   C_pin
D1   VDD   POWER   68.3m   3.11nH   0.27pF
D2   NC   NC   NA   NA   NA
D3   VSS   GND   49.8m   1.57nH   0.35pF
D7   VSSQ   GND   49.2m   1.56nH   0.28pF
D8   NU,UDQS#   DQS#   62.1m   2.29nH   0.31pF
D9   VDDQ   POWER   73.4m   3.05nH   0.38pF
E1   DQ14   DQ   69.0m   2.90nH   0.36pF
E2   VSSQ   GND   57.2m   2.10nH   0.30pF
E3   UDM   DM   44.8m   1.38nH   0.22pF
E7   UDQS   DQ   50.5m   1.47nH   0.25pF
E8   VSSQ   GND   61.2m   2.18nH   0.37pF
E9   DQ15   DQ   73.1m   2.97nH   0.37pF
F1   VDDQ   POWER   68.3m   2.84nH   0.35pF
F2   DQ9   DQ   56.9m   2.03nH   0.28pF
F3   VDDQ   POWER   44.9m   1.33nH   0.35pF
F7   VDDQ   POWER   49.3m   1.40nH   0.37pF
F8   DQ8   DQ   61.1m   2.16nH   0.30pF
F9   VDDQ   POWER   71.9m   2.94nH   0.36pF
G1   DQ12   DQ   68.8m   2.86nH   0.36pF
G2   VSSQ   GND   57.2m   2.05nH   0.36pF
G3   DQ11   DQ   45.6m   1.29nH   0.22pF
G7   DQ10   DQ   49.0m   1.40nH   0.23pF
G8   VSSQ   GND   60.0m   2.10nH   0.36pF
G9   DQ13   DQ   71.5m   2.95nH   0.35pF
H1   VDD   POWER   68.2m   2.81nH   0.35pF
H2   NC   NC   NA   NA   NA
H3   VSS   GND   45.1m   1.28nH   0.35pF
H7   VSSQ   GND   48.4m   1.42nH   0.36pF
H8   NU,LDQS#   DQS#   60.8m   2.18nH   0.30pF
H9   VDDQ   POWER   71.6m   2.96nH   0.36pF
J1   DQ6   DQ   68.0m   2.78nH   0.35pF
J2   VSSQ   GND   56.2m   2.00nH   0.35pF
J3   LDM   DM   44.7m   1.27nH   0.21pF
J7   LDQS   DQ   48.9m   1.37nH   0.22pF
J8   VSSQ   GND   60.3m   2.10nH   0.37pF
J9   DQ7   DQ   72.0m   2.89nH   0.35pF
K1   VDDQ   POWER   55.9m   1.98nH   0.36pF
K2   DQ1   DQ   56.9m   2.00nH   0.29pF
K3   VDDQ   POWER   44.6m   1.25nH   0.35pF
K7   VDDQ   POWER   48.3m   1.35nH   0.35pF
K8   DQ0   DQ   60.4m   2.09nH   0.30pF
K9   VDDQ   POWER   71.4m   2.91nH   0.36pF
L1   DQ4   DQ   67.7m   2.75nH   0.35pF
L2   VSSQ   GND   67.4m   2.77nH   0.35pF
L3   DQ3   DQ   44.5m   1.24nH   0.21pF
L7   DQ2   DQ   48.0m   1.38nH   0.22pF
L8   VSSQ   GND   59.9m   2.09nH   0.37pF
L9   DQ5   DQ   71.6m   2.86nH   0.36pF
M1   VDDL   POWER   66.2m   2.76nH   0.33pF
M2   VREF   POWER   55.9m   1.96nH   0.37pF
M3   VSS   GND   43.8m   1.23nH   0.37pF
M7   VSSDL   GND   48.0m   1.35nH   0.36pF
M8   CK   CLKIN_800   60.6m   2.10nH   0.29pF
M9   VDD   POWER   80.1m   3.25nH   0.41pF
N2   CKE   IN_800   53.8m   2.05nH   0.23pF
N3   WE#   IN_800   43.2m   1.24nH   0.19pF
N7   RAS#   IN_800   48.4m   1.33nH   0.22pF
N8   CK#   CLKIN_800   59.9m   2.07nH   0.29pF
N9   ODT   IN_800   72.1m   2.91nH   0.37pF
P1   RFU   NC   NA   NA   NA
P2   BA0   IN_800   53.9m   1.98nH   0.24pF
P3   BA1   IN_800   43.2m   1.26nH   0.19pF
P7   CAS#   IN_800   47.6m   1.38nH   0.21pF
P8   CS#   IN_800   59.9m   2.15nH   0.34pF
R2   A10   IN_800   55.9m   2.04nH   0.25pF
R3   A1   IN_800   43.2m   1.24nH   0.19pF
R7   A2   IN_800   47.2m   1.33nH   0.21pF
R8   A0   IN_800   58.9m   2.08nH   0.26pF
R9   VDD   POWER   70.4m   2.91nH   0.32pF
T1   VSS   GND   9.9m   0.47nH   0.07pF
T2   A3   IN_800   57.7m   2.10nH   0.27pF
T3   A5   IN_800   45.6m   1.32nH   0.21pF
T7   A6   IN_800   49.1m   1.40nH   0.23pF
T8   A4   IN_800   60.9m   2.12nH   0.28pF
U2   A7   IN_800   60.5m   2.15nH   0.32pF
U3   A9   IN_800   48.5m   1.43nH   0.25pF
U7   A11   IN_800   52.4m   1.58nH   0.25pF
U8   A8   IN_800   63.6m   2.30nH   0.32pF
U9   VSS   GND   71.2m   3.01nH   0.29pF
V1   VDD   POWER   71.4m   3.28nH   0.27pF
V2   A12   IN_800   58.8m   2.21nH   0.28pF
V3   RFU   NC   NA   NA   NA
V7   RFU   NC   NA   NA   NA
V8   RFU   NC   NA   NA   NA
|**********************DIFF PIN*********************************************
[Diff_pin]   inv_pin   vdiff   tdelay_typ   tdelay_min   tdelay_max
   M8   N8   .250V   0ns   NA   NA
   E7   D8   .250V   0ns   NA   NA
|  Pins E7 and D8 are a differential I/O only when DQS# is enabled via MRS
|  If DQS# is disabled, then E7(UDQS) is a single ended I/O and D8 is a NC
   J7   H8   .250V   0ns   NA   NA
|  Pins J7 and H8 are a differential I/O only when DQS# is enabled via MRS
|  If DQS# is disabled, then J7(LDQS) is a single ended I/O and H8 is a NC
|   Model Selector
[Model Selector] DM
DM_IN_800   DM input model
DM_ODT50_800   DM Input model with 50 Ohm ODT Submodel
DM_ODT75_800   DM Input model with 75 Ohm ODT Submodel
DM_ODT150_800   DM Input model with 150 Ohm ODT Submodel
[Model Selector] DQ
DQ_FULL_800   Full-Strength IO Driver with no ODT
DQ_FULL_ODT50_800   Full-Strength IO Driver with 50 Ohm ODT Submodel
DQ_FULL_ODT75_800   Full-Strength IO Driver with 75 Ohm ODT Submodel
DQ_FULL_ODT150_800   Full-Strength IO Driver with 150 Ohm ODT Submodel
DQ_HALF_800   Reduced-Strength IO Driver with no ODT
DQ_HALF_ODT50_800   Reduced-Strength IO Driver with 50 Ohm ODT Submodel
DQ_HALF_ODT75_800   Reduced-Strength IO Driver with 75 Ohm ODT Submodel
DQ_HALF_ODT150_800   Reduced-Strength IO Driver with 150 Ohm ODT Submodel
[Model Selector] DQS#
DQ_FULL_800   Full-Strength IO Driver with no ODT
DQ_FULL_ODT50_800   Full-Strength IO Driver with 50 Ohm ODT Submodel
DQ_FULL_ODT75_800   Full-Strength IO Driver with 75 Ohm ODT Submodel
DQ_FULL_ODT150_800   Full-Strength IO Driver with 150 Ohm ODT Submodel
DQ_HALF_800   Reduced-Strength IO Driver with no ODT
DQ_HALF_ODT50_800   Reduced-Strength IO Driver with 50 Ohm ODT Submodel
DQ_HALF_ODT75_800   Reduced-Strength IO Driver with 75 Ohm ODT Submodel
DQ_HALF_ODT150_800   Reduced-Strength IO Driver with 150 Ohm ODT Submodel
NF_IN_800   (Use to disable DQS#)
| Models and submodels in the file (20): DQ_FULL_800 (I/O), DQ_FULL_ODT50_800 (I/O), DQ_FULL_ODT75_800 (I/O), DQ_FULL_ODT150_800 (I/O), DQ_HALF_800 (I/O), DQ_HALF_ODT50_800 (I/O), DQ_HALF_ODT75_800 (I/O), DQ_HALF_ODT150_800 (I/O), RDQS_FULL_800 (3-state), RDQS_HALF_800 (3-state), DM_IN_800 (Input), DM_ODT50_800 (Input), DM_ODT75_800 (Input), DM_ODT150_800 (Input), IN_800 (Input), CLKIN_800 (Input), NF_IN_800 (Terminator), 50ohm_ODT_800 (Dynamic_clamp), 75ohm_ODT_800 (Dynamic_clamp), 150ohm_ODT_800 (Dynamic_clamp)
