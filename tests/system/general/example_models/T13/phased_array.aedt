# Ansys Electronics Desktop project, version 2023.2
materials:
  vacuum: permittivity=1

design array (HFSS, HFSS Hybrid Modal Network, model units cm)
variables:
  airbox_Z = 0.25cm
  ScanFrequency = 1800000000Hz
  ScanAngleTheta = 0deg
  ScanAnglePhi = 0deg
  ScanPhaseShiftA = -((ScanFrequency*0.0*sin(ScanAngleTheta)*cos(ScanAnglePhi)) + (ScanFrequency*1.25750701317e-09*sin(ScanAngleTheta)*sin(ScanAnglePhi))) rad
  ScanPhaseShiftB = -((ScanFrequency*1.25750701317e-09*sin(ScanAngleTheta)*cos(ScanAnglePhi)) + (ScanFrequency*0.0*sin(ScanAngleTheta)*sin(ScanAnglePhi))) rad
  ScanMag1 = 1W
  ScanPhase1 = 0deg
geometry:
  01_Metal_Only_NEW1 = component(01_Metal_Only_NEW, 3D_Component_File_Path=D:/R2023R2_Parfect_Pitch/01_Metal_Only_NEW.a3dcomp, subX=6cm, subY=6cm, subH=0.1524cm, patchY=4.39cm, airbox_Z=airbox_Z)
  sub [Rogers RO4003 (tm)] = part_of(01_Metal_Only_NEW1)
  Ground, antenna, Box1 [vacuum] = part_of(01_Metal_Only_NEW1)
  02_Patch_NEW1 = component(02_Patch_NEW, 3D_Component_File_Path=D:/R2023R2_Parfect_Pitch/02_Patch_NEW.a3dcomp, subX=6cm, subY=6cm, subH=0.1524cm, patchY=4.39cm, FeedWidth=0.336cm, InsetGap=0.168cm, InsetDistance=1.46cm, FeedLength=1.5cm, airbox_Z=airbox_Z, feed_correct=0.85cm)
  sub_1 [Rogers RO4003 (tm)] = part_of(02_Patch_NEW1)
  Ground_1, antenna_1, port1, Box1_1 [vacuum] = part_of(02_Patch_NEW1)
  03_Radome_Side_New1 = component(03_Radome_Side_New, 3D_Component_File_Path=D:/R2023R2_Parfect_Pitch/03_Radome_Side_New.a3dcomp, subX=6cm, subY=6cm, subH=0.1524cm, airbox_Z=airbox_Z)
  sub_2 [Rogers RO4003 (tm)] = part_of(03_Radome_Side_New1)
  Ground_2, Box1_2 [vacuum] = part_of(03_Radome_Side_New1)
  04_Radome_Corner_NEW1 = component(04_Radome_Corner_NEW, 3D_Component_File_Path=D:/R2023R2_Parfect_Pitch/04_Radome_Corner_NEW.a3dcomp, subX=6cm, subY=6cm, subH=0.1524cm, airbox_Z=airbox_Z)
  sub_3 [Rogers RO4003 (tm)] = part_of(04_Radome_Corner_NEW1)
  Ground_3, Box1_3 [vacuum] = part_of(04_Radome_Corner_NEW1)
  Rectangle1 [non-model] = rectangle(corner=(-24cm, -24cm, 0.1524cm), x_size=48cm, y_size=48cm)
  Radome1 = component(Radome, 3D_Component_File_Path=D:/R2023R2_Parfect_Pitch/Radome.a3dcomp)
  Box2 [Teflon (tm)] = part_of(Radome1)
  Radome1.move(TranslateVectorX=0cm TranslateVectorY=0cm TranslateVectorZ=0.25cm)
  Aluminum_Base1 = component(Aluminum_Base, 3D_Component_File_Path=D:/R2023R2_Parfect_Pitch/Aluminum_Base.a3dcomp, subY=6cm, subX=6cm)
  Box6 [aluminum] = part_of(Aluminum_Base1)
  coordinate_system AB_CS = origin=(0cm, 0cm, -411.48cm/2) x=(1cm, 0cm, 0cm) y=(0cm, 1cm, 0cm)
  coordinate_system NearField_CS = origin=(118.68cm, 0cm, -10cm) x=(1cm, 0cm, 0cm) y=(0cm, 1cm, 0cm) in AB_CS
  SubRegion [vacuum] = sub_region(of=Ground_3, sub_1, sub, Ground_1, Ground, antenna_1, antenna, Box1, port1, Box1_1, sub_2, Rectangle1, Ground_2, Box1_2, Box6, sub_3, Box1_3, Box2, absolute_offset: +X=5.5555556cm, -X=5.5555556cm, +Y=5.5555556cm, -Y=5.5555556cm, +Z=5.5555556cm, -Z=1cm)
  coordinate_system RelativeCS1 = origin=(10cm, 0cm, 0cm) x=(1cm, 0cm, 0cm) y=(0cm, 1cm, 0cm)
  01_Metal_Only_NEW1.move(TranslateVectorX=-0.09 TranslateVectorY=-0.06 TranslateVectorZ=0)
  02_Patch_NEW1.move(TranslateVectorX=-0.15 TranslateVectorY=-0.12 TranslateVectorZ=0)
  03_Radome_Side_New1.move(TranslateVectorX=-0.03 TranslateVectorY=0.06 TranslateVectorZ=0)
  04_Radome_Corner_NEW1.move(TranslateVectorX=-0.15 TranslateVectorY=-0.18 TranslateVectorZ=0)
boundaries and excitations:
  01_Metal_Only_NEW1_groundMetal: Perfect E Objects=Ground
  01_Metal_Only_NEW1_Antenna: Perfect E Objects=antenna
  01_Metal_Only_NEW1_LatticePair1: Lattice Pair Faces=Box1.face(at (-9, -9, 0.2012), at (-9, -3, 0.2012)) CoordSysVector{(-12, -9, 0.4024) -> (-12, -9, 0)} ReverseV PhaseDelay=UseScanAngle Phi=0deg Theta=0deg
  01_Metal_Only_NEW1_LatticePair2: Lattice Pair Faces=Box1.face(at (-12, -6, 0.2012), at (-6, -6, 0.2012)) CoordSysVector{(-12, -3, 0.4024) -> (-12, -3, 0)} ReverseV PhaseDelay=UseScanAngle Phi=0deg Theta=0deg
  02_Patch_NEW1_antennaMetal: Perfect E Objects=antenna_1
  02_Patch_NEW1_groundMetal: Perfect E Objects=Ground_1
  02_Patch_NEW1_LatticePair1: Lattice Pair Faces=Box1_1.face(at (-15, -15, 0.2012), at (-15, -9, 0.2012)) CoordSysVector{(-18, -15, 0.4024) -> (-18, -15, 0)} ReverseV PhaseDelay=UseScanAngle Phi=0deg Theta=0deg
  02_Patch_NEW1_LatticePair2: Lattice Pair Faces=Box1_1.face(at (-18, -12, 0.2012), at (-12, -12, 0.2012)) CoordSysVector{(-18, -9, 0.4024) -> (-18, -9, 0)} ReverseV PhaseDelay=UseScanAngle Phi=0deg Theta=0deg
  03_Radome_Side_New1_groundMetal: Perfect E Objects=Ground_2
  03_Radome_Side_New1_LatticePair1: Lattice Pair Faces=Box1_2.face(at (-3, 3, 0.2012), at (-3, 9, 0.2012)) CoordSysVector{(-6, 3, 0.4024) -> (-6, 3, 0)} ReverseV PhaseDelay=UseScanAngle Phi=0deg Theta=0deg
  03_Radome_Side_New1_LatticePair2: Lattice Pair Faces=Box1_2.face(at (-6, 6, 0.2012), at (0, 6, 0.2012)) CoordSysVector{(-6, 9, 0.4024) -> (-6, 9, 0)} ReverseV PhaseDelay=UseScanAngle Phi=0deg Theta=0deg
  04_Radome_Corner_NEW1_groundMetal: Perfect E Objects=Ground_3
  04_Radome_Corner_NEW1_LatticePair1: Lattice Pair Faces=Box1_3.face(at (-15, -21, 0.2012), at (-15, -15, 0.2012)) CoordSysVector{(-18, -21, 0.4024) -> (-18, -21, 0)} ReverseV PhaseDelay=UseScanAngle Phi=0deg Theta=0deg
  04_Radome_Corner_NEW1_LatticePair2: Lattice Pair Faces=Box1_3.face(at (-18, -18, 0.2012), at (-12, -18, 0.2012)) CoordSysVector{(-18, -15, 0.4024) -> (-18, -15, 0)} ReverseV PhaseDelay=UseScanAngle Phi=0deg Theta=0deg
  Rad1: Radiation Objects=SubRegion
  02_Patch_NEW1_1: Lumped Port Faces=port1.face(at (-15, -9.155, 0.0762)) LumpedPortType=Modal Modes{Mode1{IntLine{(-15, -9.155, 0.1524) -> (-15, -9.155, 0)} CharImp=Zpi}} Impedance=50ohm
array:
  Type="3D Component" Name=Array UseAirObjects RowPrimaryBnd=01_Metal_Only_NEW1_LatticePair1 ColumnPrimaryBnd=01_Metal_Only_NEW1_LatticePair2 RowDimension=7 ColumnDimension=8 ShowCellNumber RenderType=0 Padding=0 Colors(190, 33023, 258, 4227072) ComponentMap("'4'=258", "'3'=190", "'1'=5", "'2'=84") ReferenceCSID=1
  UseAbove
setups:
  Setup1: HfssDriven Frequency=1.8GHz MaxDeltaS=0.02 MaximumPasses=20 MinimumPasses=1 MinimumConvergedPasses=1 PercentRefinement=30 BasisOrder=1 PortAccuracy=2 DrivenSolverType="Domain Decomposition" IterativeResidual=1e-06 DDMSolverResidual=0.0001 SaveRadFieldsOnly InfiniteSphereSetup=33
source amplitudes:
  02_Patch_NEW1_1:1: 1W 0deg
  02_Patch_NEW1_1:2..02_Patch_NEW1_1:20: 0W 0deg
radiation setups:
  3D: Infinite Sphere Theta=0deg..180deg step 2deg Phi=0deg..360deg step 2deg
reports:
  Gain Plot 1: dB(GainTotal) vs Theta on Setup1 : LastAdaptive, 3D [Phi=0deg Freq=1800MHz]
