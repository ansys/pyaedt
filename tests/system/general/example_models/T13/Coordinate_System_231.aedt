# Ansys Electronics Desktop project, version 2023.1
materials:
  vacuum: permittivity=1

design HFSSDesign1 (HFSS, HFSS Modal Network, model units mm)
variables:
  a = 0.4mm
geometry:
  coordinate_system RelativeCS1 = origin=(-1.2mm, 1.6mm, 0mm) x=(1.2mm, 0.8mm, 0mm) y=(0mm, 0.6mm, 0mm)
  coordinate_system RelativeCS3 = origin=(-2.2mm, -1mm, 0mm) x=(1mm, 0mm, 0mm) y=(0mm, 1mm, 0mm) in RelativeCS1
  Box1, Box2 [vacuum] = imported_body()
