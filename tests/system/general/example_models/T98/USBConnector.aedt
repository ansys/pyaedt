# Ansys Electronics Desktop project, version 2024.2
project datasets:
  $ds1: (22, 1) (200, 0.6)
materials:
  Al-Extruded: thermal_conductivity=205 mass_density=2800 specific_heat=900 youngs_modulus=69000000000 poissons_ratio=0.33 thermal_expansion_coefficient=2.277e-06 thermal_material_type=Solid
  air: permittivity=1.0006 permeability=1.0000004 thermal_conductivity=0.0261 mass_density=1.1614 specific_heat=1005 thermal_expansion_coefficient=0.00333 thermal_material_type=Fluid diffusivity=2.88e-05 molecular_mass=0.028966 viscosity=1.84e-05 material_refractive_index=1.000293
  COPPER: thermal_modifier{Property=conductivity free_form_value=pwl($ds1,Temp)} conductivity=59590000 thermal_conductivity=387.6 mass_density=8933 specific_heat=397
  Teflon (tm): permittivity=2.1 dielectric_loss_tangent=0.001 thermal_conductivity=0.25 mass_density=2250 specific_heat=1400 youngs_modulus=496000000 poissons_ratio=0.3 thermal_expansion_coefficient=1.35e-06
  vacuum: permittivity=1
surface materials:
  Steel-oxidised-surface: surface_emissivity=0.8

design Icepak_GTJ (Icepak, SteadyState TemperatureAndFlow, model units mm)
options: Default_Fluid_Material=air Default_Solid_Material=Al-Extruded Default_Surface_Material=Steel-oxidised-surface AmbientTemperature=20cel AmbientPressure=0n_per_meter_sq AmbientRadiationTemperature=20cel Gravity_Vector_CS_ID=Global Gravity_Vector_Axis=Z Positive=false Altitude=0meter OperatingPressure=101325n_per_meter_sq OperatingDensity=1.225kg_per_m3
geometry:
  Region [air] = region(percentage_offset=50 on all sides)
  USB_VCC, USB_ID, USB_GND, usb_N, usb_P, USB_Shiels [COPPER] = imported_body()
  USBmale_ObjectFromFace1 [Teflon (tm)] = imported_body()
  Rectangle1, Rectangle1_1..Rectangle1_4, Rectangle2, Rectangle3_1, Rectangle3_1_1, Rectangle3_1_2, Rectangle3_1_3, Rectangle4..Rectangle7 [vacuum] = imported_body()
  group Group1 = USB_VCC, USB_ID, USB_GND, usb_N, usb_P, USB_Shiels, USBmale_ObjectFromFace1, Rectangle1, Rectangle1_1..Rectangle1_4, Rectangle2, Rectangle3_1, Rectangle3_1_1, Rectangle3_1_2, Rectangle3_1_3, Rectangle4..Rectangle7
boundaries and excitations:
  EMLoss_VD0P6Z: EM Loss Objects=[USB_VCC, USB_ID, USB_GND, usb_N, usb_P, USB_Shiels, USBmale_ObjectFromFace1, Rectangle1, Rectangle1_1..Rectangle1_4, Rectangle2, Rectangle3_1, Rectangle3_1_1, Rectangle3_1_2, Rectangle3_1_3, Rectangle4..Rectangle7] LinkID=2 Project=C:\Users\lvecchie\AppData\Local\Temp\unit_test-znkcQP-VW7JHC-XHL6zf\scratch1IU056\USB_Connector_IPK_231.aedt Product=ElectronicsDesktop Design=uUSB ForceSourceToSolve PreservePartnerSoln PathRelativeTo=TargetProject Intrinsics(2.5GHz) SurfaceOnly(35, 131, 227, 323, 419, 515, 2435, 2446, 2457, 2468, 2479, 2490, 2501, 2512, 2523, 2534, 2545, 2556, 2567, 2578) LossMultiplier=1 EnableTransientCurve
mesh:
  Global:  MeshMethod=MesherHD ComputeGap MeshRegionResolution=3 MinGapX=1mm MinGapY=1mm MinGapZ=1mm Objects=Region FacetLevel=3 ProximitySizeFunction CurvatureSizeFunction OptimizePCBMesh
