# Ansys Electronics Desktop project, version 2023.2
materials:
  Al-Extruded: thermal_conductivity=205 mass_density=2800 specific_heat=900 youngs_modulus=69000000000 poissons_ratio=0.33 thermal_expansion_coefficient=2.277e-06 thermal_material_type=Solid
  air: permittivity=1.0006 permeability=1.0000004 thermal_conductivity=0.0261 mass_density=1.1614 specific_heat=1005 thermal_expansion_coefficient=0.00333 thermal_material_type=Fluid diffusivity=2.88e-05 molecular_mass=0.028966 viscosity=1.84e-05 material_refractive_index=1.000293
surface materials:
  Steel-oxidised-surface: surface_emissivity=0.8

design IcepakDesign1 (Icepak, SteadyState TemperatureAndFlow, model units mm)
options: Default_Fluid_Material=air Default_Solid_Material=Al-Extruded Default_Surface_Material=Steel-oxidised-surface AmbientTemperature=20cel AmbientPressure=0n_per_meter_sq AmbientRadiationTemperature=20cel Gravity_Vector_CS_ID=Global Gravity_Vector_Axis=Z Positive=false Altitude=0meter
geometry:
  Region [air] = region(percentage_offset=50 on all sides)
  Heatsink1_1 = component(Heatsink1, Type=HeatSink Unit=mm MovePlane=XY FinType=Extruded FlowDirection=Length BaseLength=0.2mm BaseWidth=0.2mm BaseHeight=0.025mm OverallHeight=0.1mm FinCount=4 FinThickness=0.02mm FinOffsetOnLength=0mm FinOffsetOnWidth=0mm BaseId=6 PinIds(34, 62, 90, 118) BaseMaterial=Al-Extruded FinMaterial=Al-Extruded BaseSurfaceMaterial=Steel-oxidised-surface FinSurfaceMaterial=Steel-oxidised-surface)
  Heatsink1_Base, Heatsink1_Pin1..Heatsink1_Pin4 [Al-Extruded] = part_of(Heatsink1_1)
mesh:
  MeshRegions:  Global{MeshMethod=MesherHD ComputeGap MeshRegionResolution=3 MinGapX=1mm MinGapY=1mm MinGapZ=1mm Objects=Region FacetLevel=3 ProximitySizeFunction CurvatureSizeFunction OptimizePCBMesh}
  MeshOperations:
