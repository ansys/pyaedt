# Ansys Electronics Desktop project, version 2023.1
materials:
  vacuum: permittivity=1

design CeramicFilter (HFSS, HFSS Modal Network, model units mm)
options: Allow_Material_Override Save_Adaptive_support_files
variables:
  gap_bottom = -0.53356204mm  # optimise -0.5mm..0.4mm
  gap_top1 = 1.1993053mm  # optimise -1.5mm..1.2mm
  gap_top2 = 0.13483829mm  # optimise -1mm..1.2mm
  filletR = 0.5mm
  t = 0.035mm
  vr = 0.2mm
geometry:
  coordinate_system RelativeCS1 = origin=(2.3971mm, 1.0235mm, 8.796mm) x=(1mm, 0mm, 0mm) y=(0mm, 1mm, 0mm)
  coordinate_system RelativeCS2 = origin=(1.15885mm, 1.3826mm, 12.046mm) x=(1mm, 0mm, 0mm) y=(0mm, 1mm, 0mm)
  coordinate_system RelativeCS3 = origin=(3.33115mm, -1.4326mm, 1.75mm) x=(1mm, 0mm, 0mm) y=(0mm, 1mm, 0mm) in RelativeCS2
  via1_1 = imported_body()
  via1_1.separate_bodies()
  via1_1.delete()
  Box2, Box2_ObjectFromFace1, Cylinder1, Box2_1, Box2_2, Box2_3, Box2_ObjectFromFace1_1, Box2_ObjectFromFace1_2, Box2_ObjectFromFace1_3, Cylinder1_2, Cylinder1_3, Cylinder1_4, Polyline1, Polyline2, Polyline2_ObjectFromEdge1, Polyline1_2, Polyline2_2, Polyline3, Polyline4, Polyline3_2, Polyline4_2, Box1, Box5, Box6, Box8, Box10, via1, via2, Box11, Box12, via1_1_Separate3, Circle1, Rectangle1, Port1, Port2 [vacuum] = imported_body()
