# Ansys Electronics Desktop project, version 2023.1
materials:
  vacuum: permittivity=1
  PVC plastic: permittivity=2.7 dielectric_loss_tangent=0.007
  copper: permeability=0.999991 conductivity=58000000
  pec: conductivity=1e+30

design HFSSDesign1 (HFSS, HFSS Modal Network, model units mm)
geometry:
  Region [vacuum] = region(percentage_offset=10 on all sides)
  Rectangle1, Polyline1 [vacuum] = imported_body()
boundaries and excitations:
  PerfE1: Perfect E Objects=Rectangle1
  Rad1: Radiation Objects=Region
setups:
  Setup1: HfssDrivenAuto AutoSolverSetting=Balanced Type=Discrete
    sweep Sweep: 1Hz to 200Hz, 10 points;
field plots:
  Mag_E1: E Field over Rectangle1.face(at (0, 0, -15)) on Setup1 : LastAdaptive at Freq=1.005e-07GHz Phase=0deg
  Mag_E2: E Field over a plane on Setup1 : LastAdaptive at Freq=1.005e-07GHz Phase=0deg
