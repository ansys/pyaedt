# Ansys Electronics Desktop project, version 2022.1
materials:
  Al2_O3_ceramic: permittivity=9.8
  copper: permeability=0.999991 conductivity=58000000
  gold: permeability=0.99996 conductivity=41000000

design Diode (Circuit)
options: IntegrationMethod=FFT
components:
  R11 = RES_(R=40)
  L12 = IND_(L=1000nH)
  C13 = CAP_(C=100pF)
  C14 = CAP_(C=100pF)
  A15 = MS_TRL(W=10mil P=100mil)
  A19 = MS_TRL(W=10mil P=100mil)
  DData20 = DIODE_Level1_Model(ModelName=DiodeModel RS=0.5 VB=50 CJ=0.5pF PB=1)
  D21 = DIODE_Level1(MOD=DiodeModel)
  V23 = V_PULSE(V1=5 V2=-10 PER=1000ns PW=500ns TR=5ns TF=5ns)
  port Port1 rz=50ohm iz=0ohm EnableNoise=false noisetemp=16.85cel
  port Port2 rz=50ohm iz=0ohm EnableNoise=false noisetemp=16.85cel
nets:
  0: V23.1, D21.1
  net_11: R11.0, V23.0
  net_5: R11.1, L12.0
  net_6: C14.1, A15.0
  net_8: C13.0, A19.1
  net_9: L12.1, A15.1, D21.0, A19.0
  Port1: C14.0
  Port2: C13.1
setups:
  LNA: LinearFrequencyData(false, 0.1, false, "", false) SweepDefinition{Variable=Freq Data="LIN 0GHz 2GHz 0.1GHz"}
  Transient: FilterText="V(Port1) V(Port2) V(net_11) V(net_5) V(net_6) V(net_8) V(net_9)" OutputQuantities{Quantity{NodeType=Net CompName=Port1 QuantityName=V Selected UnitType=NoUnit TypeInfo("", 0, "", "IsUnconstrained=false")} Quantity{NodeType=Net CompName=Port2 QuantityName=V Selected UnitType=NoUnit TypeInfo("", 0, "", "IsUnconstrained=false")} Quantity{NodeType=Net CompName=net_11 QuantityName=V Selected UnitType=NoUnit TypeInfo("", 0, "", "IsUnconstrained=false")} Quantity{NodeType=Net CompName=net_5 QuantityName=V Selected UnitType=NoUnit TypeInfo("", 0, "", "IsUnconstrained=false")} Quantity{NodeType=Net CompName=net_6 QuantityName=V Selected UnitType=NoUnit TypeInfo("", 0, "", "IsUnconstrained=false")} Quantity{NodeType=Net CompName=net_8 QuantityName=V Selected UnitType=NoUnit TypeInfo("", 0, "", "IsUnconstrained=false")} Quantity{NodeType=Net CompName=net_9 QuantityName=V Selected UnitType=NoUnit TypeInfo("", 0, "", "IsUnconstrained=false")}} TransientData(1ns, 10000ns) TransientNoiseData(false, "", "", 0, 1, 0, false, 1) TransientOtherData("")
  Options: ModifiedOptions{gen_autoselsolver=no ts_abstol=1e-08 ts_vntol=0.0005 ts_reltol=0.01}
reports:
  S Parameters: dB(S(Port1,Port1)), dB(S(Port2,Port1)) vs Freq on LNA : LNA
  Time Plot: V(Port2) vs Time on Transient : Transient

design diff (Circuit)
options: SParamCircuitDef IntegrationMethod=FFT
variables:
  w1 = 1mm
  l1 = 10mm
components:
  W5493 = MS_MCPL_DIFF(W=w1 L=l1)
  port Port1 rz=50ohm iz=0ohm EnableNoise=false noisetemp=16.85cel
  port Port2 rz=50ohm iz=0ohm EnableNoise=false noisetemp=16.85cel
  port Port3 rz=50ohm iz=0ohm EnableNoise=false noisetemp=16.85cel
  port Port4 rz=50ohm iz=0ohm EnableNoise=false noisetemp=16.85cel
nets:
  Port1: W5493.0
  Port2: W5493.1
  Port3: W5493.2
  Port4: W5493.3
setups:
  LinearFrequency: LinearFrequencyData(false, 0.1, false, "", false) SweepDefinition{Variable=Freq Data="LINC 1GHz 10GHz 101"} SweepDefinition{Variable=l1 Data="LINC 10mm 50mm 5"}
