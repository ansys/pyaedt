# Ansys Electronics Desktop project, version 2023.1
project variables:
  $height = 10mm
  $dim = 5mm
project datasets:
  $my_materialconductivityTH0: (22, 1) (80, 0.8)
  $AluminumpermittivityTH0: (22, 1) (200, 0.6) (400, 0.39)
  $AluminumconductivityTH0: (22, 1) (200, 0.6) (400, 0.39)
  $AluminumconductivityFM0: (1000000000, 38000000) (2000000000, 38000000) (3000000000, 38000000)
materials:
  Al2_O3_ceramic: permittivity=9.8
  Aluminum: thermal_modifier{Property=permittivity free_form_value=pwl($AluminumpermittivityTH0,Temp)} thermal_modifier{Property=conductivity free_form_value=pwl($AluminumconductivityTH0,Temp)} permittivity{anisotropic component1=1 component2=1 component3=1} permeability=1.000021 conductivity=pwl($AluminumconductivityFM0,Freq)
  copper: permeability=0.999991 conductivity=58000000
  gold: permeability=0.99996 conductivity=41000000
  my_material: thermal_modifier{Property=conductivity free_form_value=pwl($my_materialconductivityTH0,Temp)} permittivity=1 permeability=1 conductivity=650000000
  teflon_based: permittivity=2.08 dielectric_loss_tangent=0.001
  vacuum: permittivity=1

design HFSSDesign (HFSS, HFSS Modal Network, model units mm)
options: Save_Adaptive_support_files
variables:
  height = 5mm
  dim = 5mm
geometry:
  inner [Aluminum] = imported_body()
  NewObject_IJD39Q [teflon_based] = imported_body()
  outer [Aluminum] = imported_body()
  NewObject_V7O4LE, NewObject_N4W2EG [vacuum] = imported_body()
boundaries and excitations:
  1: Wave Port Faces=?.face(#17) NumModes=1 Modes{Mode1{CharImp=Zpi}}
  2: Wave Port Faces=?.face(#18) NumModes=1 Modes{Mode1{CharImp=Zpi}}
mesh:
  ModelResolution1: DefeatureBased Objects=[inner, outer] auto length
  Length2: LengthBased Faces=?.face(#59, #16, #17, #18) NumMaxElem=2000 MaxLength=1mm
  initial mesh: GlobalSurfApproximation{CurvedSurfaceApproxChoice=UseSlider SliderMeshSettings=6}
source amplitudes:
  1:1: 1W 0deg
  2:1: 0W 0deg

design Circuit1 (Circuit)
options: SParamCircuitDef IntegrationMethod=FFT
components:
  C3 = CAP_()
  R4 = RES_()
  port Port1 rz=50ohm iz=0ohm EnableNoise=false noisetemp=16.85cel
nets:
  0: C3.1, R4.1
  Port1: C3.0, R4.0
