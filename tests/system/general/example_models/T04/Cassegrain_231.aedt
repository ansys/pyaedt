# Ansys Electronics Desktop project, version 2023.1
materials:
  vacuum: permittivity=1
  pec: conductivity=1e+30

design Cassegrain_reflectors (HFSS, SBR+, model units cm)
options: Allow_Material_Override Save_Adaptive_support_files
variables:
  # --Feed Selection
  Swing_Angle = 0deg
  # --Primary Reflector
  Diameter_Primary = 70cm
  Focal_Length = 50cm
  # --Secondary Reflector
  Eccentricity = 2
  Interfocal_Distance = 25cm
  M = (Eccentricity+1)/(Eccentricity-1)
  Feed_Tilt = 2*atan(M*tan(Swing_Angle/2))
  Offset_Primary = (-2*Focal_Length)*((tan(Swing_Angle/2)-M*tan(Feed_Tilt/2))/(1+M*tan(Swing_Angle/2)*tan(Feed_Tilt/2)))
  C_Subreflector = Interfocal_Distance/2
  A_Subreflector = C_Subreflector/Eccentricity
  C_ebc = C_Subreflector/1cm
  A_ebc = A_Subreflector/1cm
  B_Subreflector = sqrt(C_Subreflector^2 - A_Subreflector^2)
  B_ebc = sqrt(C_ebc^2 - A_ebc^2)
  Psi_U = -2*atan((2*Offset_Primary + Diameter_Primary) / (4*Focal_Length))
  Theta_E = abs(2*atan((1/M)*tan((Psi_U-Swing_Angle)/2))+Feed_Tilt)
  H_Cone = 5*Interfocal_Distance
geometry:
  coordinate_system Feed_Tilt_CS = origin=(0mm, -Interfocal_Distance*cos(Swing_Angle), -Interfocal_Distance*sin(Swing_Angle)) x=(1cm, 0cm, 0cm) y=(0cm, 1cm, 0cm)
  coordinate_system feederPosition = origin=(0cm, -35.62228cm, 0cm) x=(2.74828cm, 0cm, 0cm) y=(0cm, 0cm, -2.24028cm)
  Reflector, Subreflector [vacuum] = imported_body()
radiation setups:
  ATK_2D: Infinite Sphere Theta=-180deg..180deg step 1deg Phi=0deg..90deg step 90deg
  ATK_3D: Infinite Sphere Theta=-180deg..180deg step 2deg Phi=0deg..180deg step 5deg
  Infinite Sphere1: Infinite Sphere Theta=-180deg..180deg step 2deg Phi=0deg..180deg step 2deg

design feeder (HFSS, HFSS Hybrid Modal Network, model units cm)
options: Allow_Material_Override Save_Adaptive_support_files
variables:
  # --Feed Selection
  Swing_Angle = 0deg
  # --Primary Reflector
  Diameter_Primary = 70cm
  Focal_Length = 50cm
  # --Secondary Reflector
  Eccentricity = 2
  Interfocal_Distance = 25cm
  M = (Eccentricity+1)/(Eccentricity-1)
  Feed_Tilt = 2*atan(M*tan(Swing_Angle/2))
  Offset_Primary = (-2*Focal_Length)*((tan(Swing_Angle/2)-M*tan(Feed_Tilt/2))/(1+M*tan(Swing_Angle/2)*tan(Feed_Tilt/2)))
  C_Subreflector = Interfocal_Distance/2
  A_Subreflector = C_Subreflector/Eccentricity
  C_ebc = C_Subreflector/1cm
  A_ebc = A_Subreflector/1cm
  B_Subreflector = sqrt(C_Subreflector^2 - A_Subreflector^2)
  B_ebc = sqrt(C_ebc^2 - A_ebc^2)
  Psi_U = -2*atan((2*Offset_Primary + Diameter_Primary) / (4*Focal_Length))
  Theta_E = abs(2*atan((1/M)*tan((Psi_U-Swing_Angle)/2))+Feed_Tilt)
  H_Cone = 5*Interfocal_Distance
geometry:
  coordinate_system Feed_Tilt_CS = origin=(0mm, -Interfocal_Distance*cos(Swing_Angle), -Interfocal_Distance*sin(Swing_Angle)) x=(1cm, 0cm, 0cm) y=(0cm, 1cm, 0cm)
  Pyramidal1 = component(Pyramidal, 3D_Component_File_Path=<syslib>\ACT\ATKDesign\Lib\Plugins\Reflector\feeds\Pyramidal.a3dcomp, Airbox_dist=0.118in)
  WG_inner [vacuum] = part_of(Pyramidal1)
  WG_outer, Port_Cap [pec] = part_of(Pyramidal1)
  port1, Region [vacuum] = part_of(Pyramidal1)
  Pyramidal1.rotate(RotateAxis=X RotateAngle=-90deg)
  Pyramidal1.move(TranslateVectorX=0cm TranslateVectorY=-Interfocal_Distance TranslateVectorZ=0cm)
  Pyramidal1.rotate(RotateAxis=X RotateAngle=Swing_Angle)
  Pyramidal1.rotate(RotateAxis=X RotateAngle=Feed_Tilt) in Feed_Tilt_CS
  Pyramidal1.move(TranslateVectorX=0cm TranslateVectorY=35.62228cm TranslateVectorZ=0cm)
  Pyramidal1.rotate(RotateAxis=X RotateAngle=90deg)
boundaries and excitations:
  Pyramidal1_Rad1: FE-BI Objects=Region UseAdaptiveIE
  Pyramidal1_p1: Wave Port Objects=port1 NumModes=1 Modes{Mode1{IntLine{(0, -0.508, 0.46228) -> (0, 0.508, 0.46228)} CharImp=Zpv}}
setups:
  ATK_Solution: HfssDriven Frequency=10GHz MaxDeltaS=0.02 MaximumPasses=5 MinimumPasses=1 MinimumConvergedPasses=1 PercentRefinement=30 BasisOrder=1 PortAccuracy=2 DrivenSolverType="Domain Decomposition" IterativeResidual=1e-06 DDMSolverResidual=0.0001 IESolverType=ACA
    sweep FF_Sweep: 9.2GHz to 10.8GHz, 3 points; disabled Type=Discrete SaveFields
    sweep SParam_Sweep: 9.2GHz to 10.8GHz, 100 points; disabled Type=Interpolating InterpTolerance=0.5 InterpMaxSolns=250 InterpUsePortImped=false PassivityErrorTolerance=0.0001
source amplitudes:
  Pyramidal1_p1:1: 1W 0deg
radiation setups:
  ATK_2D: Infinite Sphere Theta=-180deg..180deg step 1deg Phi=0deg..90deg step 90deg
  ATK_3D: Infinite Sphere Theta=-180deg..180deg step 2deg Phi=0deg..180deg step 5deg
reports:
  ff_3D_GainTotal: dB(GainTotal) vs Phi, Theta on ATK_Solution : LastAdaptive, ATK_3D [Freq=1e+10]
  ff_2D_GainTotal: dB(GainTotal) vs Theta on ATK_Solution : LastAdaptive, ATK_2D [Phi=all Freq=1e+10]
  ff_2D_GainTotal_Stacked: dB(GainTotal) vs Theta on ATK_Solution : FF_Sweep, ATK_2D [Phi=all Freq=all]
  Return Loss: dB(S11) vs Freq on ATK_Solution : SParam_Sweep
  Input Impedance: S11 on ATK_Solution : SParam_Sweep [Freq=all]
