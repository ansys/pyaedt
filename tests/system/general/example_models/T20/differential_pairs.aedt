# Ansys Electronics Desktop project, version 2022.2
materials:
  copper: permeability=0.999991 conductivity=58000000
  FR4: permittivity=4.35 dielectric_loss_tangent=0.02
  FR4_epoxy: permittivity=4.4 dielectric_loss_tangent=0.02
  pec: conductivity=1e+30
  vacuum: permittivity=1

design Hfss_Terminal (HFSS, DrivenTerminal, model units mm)
options: Allow_Material_Override Save_Adaptive_support_files
geometry:
  outer, left, right [pec] = imported_body(D:\10.Consulting\Rosenberger\PoC - only Python scripts\diff\CAD\simulation_stanzil.asm)
  port1_sheet [pec] = object_from(?.edge(#24))
  al_dummy_sim2hmtd_ObjectFromEdge2 = object_from(?.edge(#25))
  al_dummy_sim2hmtd_ObjectFromEdge3 = object_from(?.edge(#26))
  al_dummy_sim2hmtd_ObjectFromEdge4 = object_from(?.edge(#27))
  port1_sheet.unite(al_dummy_sim2hmtd_ObjectFromEdge2, al_dummy_sim2hmtd_ObjectFromEdge3, al_dummy_sim2hmtd_ObjectFromEdge4)
  port1_sheet.cover_lines()
  port2_sheet [pec] = object_from(?.edge(#32))
  al_dummy_sim2hmtd_ObjectFromEdge6 = object_from(?.edge(#33))
  al_dummy_sim2hmtd_ObjectFromEdge7 = object_from(?.edge(#34))
  al_dummy_sim2hmtd_ObjectFromEdge8 = object_from(?.edge(#35))
  port2_sheet.unite(al_dummy_sim2hmtd_ObjectFromEdge6, al_dummy_sim2hmtd_ObjectFromEdge7, al_dummy_sim2hmtd_ObjectFromEdge8)
  port2_sheet.cover_lines()
  group body = outer, left, right, port1_sheet, port2_sheet
boundaries and excitations:
  P1_T1: Terminal port=P1 Faces=?.face(#120) TerminalResistance=50ohm
  P1_T2: Terminal port=P1 Faces=?.face(#172) TerminalResistance=50ohm
  P2_T1: Terminal port=P2 Faces=?.face(#111) TerminalResistance=50ohm
  P2_T2: Terminal port=P2 Faces=?.face(#163) TerminalResistance=50ohm
  P1: Wave Port Faces=port1_sheet.face(at (0, 0, 1)) NumModes=1
  P2: Wave Port Faces=port2_sheet.face(at (0, 0, 0)) NumModes=1
  1: Lumped Port Objects=port1_sheet Impedance=50ohm
  2: Lumped Port Objects=port2_sheet Impedance=50ohm
  reference conductors: outer
setups:
  Setup1: HfssDriven Frequency=5GHz MaxDeltaS=0.02 MaximumPasses=6 MinimumPasses=1 MinimumConvergedPasses=1 PercentRefinement=30 BasisOrder=1 PortAccuracy=2 DrivenSolverType="Direct Solver"
    sweep Sweep: 2.5GHz to 7.5GHz, 5 points; Type=Interpolating InterpTolerance=0.5 InterpMaxSolns=250 PassivityErrorTolerance=0.0001
source amplitudes:
  P1:1: 1 0deg
  P1:2, P2:1, P2:2: 0V 0deg

design Hfss_Transient (HFSS, DrivenTerminal, model units mm)
options: Allow_Material_Override Save_Adaptive_support_files
geometry:
  outer, left, right [pec] = imported_body(D:\10.Consulting\Rosenberger\PoC - only Python scripts\diff\CAD\simulation_stanzil.asm)
  port1_sheet [pec] = object_from(?.edge(#24))
  al_dummy_sim2hmtd_ObjectFromEdge2 = object_from(?.edge(#25))
  al_dummy_sim2hmtd_ObjectFromEdge3 = object_from(?.edge(#26))
  al_dummy_sim2hmtd_ObjectFromEdge4 = object_from(?.edge(#27))
  port1_sheet.unite(al_dummy_sim2hmtd_ObjectFromEdge2, al_dummy_sim2hmtd_ObjectFromEdge3, al_dummy_sim2hmtd_ObjectFromEdge4)
  port1_sheet.cover_lines()
  port2_sheet [pec] = object_from(?.edge(#32))
  al_dummy_sim2hmtd_ObjectFromEdge6 = object_from(?.edge(#33))
  al_dummy_sim2hmtd_ObjectFromEdge7 = object_from(?.edge(#34))
  al_dummy_sim2hmtd_ObjectFromEdge8 = object_from(?.edge(#35))
  port2_sheet.unite(al_dummy_sim2hmtd_ObjectFromEdge6, al_dummy_sim2hmtd_ObjectFromEdge7, al_dummy_sim2hmtd_ObjectFromEdge8)
  port2_sheet.cover_lines()
  group body = outer, left, right, port1_sheet, port2_sheet
boundaries and excitations:
  P1_T1: Terminal port=P1 Faces=?.face(#120) TerminalResistance=50ohm
  P1_T2: Terminal port=P1 Faces=?.face(#172) TerminalResistance=50ohm
  P2_T1: Terminal port=P2 Faces=?.face(#111) TerminalResistance=50ohm
  P2_T2: Terminal port=P2 Faces=?.face(#163) TerminalResistance=50ohm
  P1: Wave Port Faces=port1_sheet.face(at (0, 0, 1)) NumModes=1
  P2: Wave Port Faces=port2_sheet.face(at (0, 0, 0)) NumModes=1
  1: Lumped Port Objects=port1_sheet Impedance=50ohm
  2: Lumped Port Objects=port2_sheet Impedance=50ohm
  reference conductors: outer
setups:
  Setup1: HfssDriven Frequency=5GHz MaxDeltaS=0.02 MaximumPasses=6 MinimumPasses=1 MinimumConvergedPasses=1 PercentRefinement=30 BasisOrder=1 PortAccuracy=2 DrivenSolverType="Direct Solver"
    sweep Sweep: 2.5GHz to 7.5GHz, 5 points; Type=Interpolating InterpTolerance=0.5 InterpMaxSolns=250 PassivityErrorTolerance=0.0001
source amplitudes:
  P1:1: 1 0deg
  P1:2, P2:1, P2:2: 0V 0deg

design EMDesign1 (HFSS 3D Layout)
ports:
  Port1, Port2: Properties{Impedance=50ohm Magnitude=1V Phase=0deg Renormalize_Impedence="50ohm + 0i ohm" Renormalize Deembed_Distance=0mm Deembed Type="Single Strip Gap Source" HFSS_Type=Gap Orientation=Vertical Layer_Alignment=Upper Horizontal_Extent_Factor=5 Vertical_Extent_Factor=3 PEC_Launch_Width=0.5mm} Type=EdgePort
  Port3, Port4: Properties{Impedance=50ohm Magnitude=1V Phase=0deg Renormalize_Impedence="50ohm + 0i ohm" Renormalize Deembed_Distance=0mm Deembed Type="Single Strip Gap Source" HFSS_Type=Gap Orientation=Vertical Layer_Alignment=Upper Horizontal_Extent_Factor=5 Vertical_Extent_Factor=3 PEC_Launch_Width=0.4mm} Type=EdgePort
  Port5, Port6: Properties{Impedance=50ohm Magnitude=1V Phase=0deg Renormalize_Impedence="50ohm + 0i ohm" Renormalize Deembed_Distance=0mm Deembed Type="Single Strip Gap Source" HFSS_Type=Gap Orientation=Vertical Layer_Alignment=Upper Horizontal_Extent_Factor=5 Vertical_Extent_Factor=3 PEC_Launch_Width=0.6mm} Type=EdgePort

design Circuit1 (Circuit)
options: SParamCircuitDef IntegrationMethod=FFT
components:
  C2 = CAP_()
  C3 = CAP_()
  C4 = CAP_()
  port Port1 rz=50ohm iz=0ohm EnableNoise=false noisetemp=16.85cel
  port Port2 rz=50ohm iz=0ohm EnableNoise=false noisetemp=16.85cel
  port Port3 rz=50ohm iz=0ohm EnableNoise=false noisetemp=16.85cel
  port Port4 rz=50ohm iz=0ohm EnableNoise=false noisetemp=16.85cel
  port Port5 rz=50ohm iz=0ohm EnableNoise=false noisetemp=16.85cel
  port Port6 rz=50ohm iz=0ohm EnableNoise=false noisetemp=16.85cel
nets:
  Port1: C2.0
  Port2: C2.1
  Port3: C3.0
  Port4: C3.1
  Port5: C4.0
  Port6: C4.1
