# Ansys Electronics Desktop project, version 2023.2
materials:
  vacuum: permittivity=1
  Rogers RO4003 (tm): permittivity=3.55 dielectric_loss_tangent=0.0027
  Teflon (tm): permittivity=2.1 dielectric_loss_tangent=0.001
  pec: conductivity=1e+30
  aluminum: permeability=1.000021 conductivity=38000000
  glass: permittivity=5.5
  gold: permeability=0.99996 conductivity=41000000
  titanium: permeability=1.00018 conductivity=1820000

design Array (HFSS, HFSS Hybrid Modal Network, model units cm)
variables:
  subX = 8cm
  subY = 8cm
  ScanFrequency = 1800000000Hz
  ScanAngleTheta = 0deg
  ScanAnglePhi = 0deg
  ScanPhaseShiftA = -((ScanFrequency*0.0*sin(ScanAngleTheta)*cos(ScanAnglePhi)) + (ScanFrequency*1.67667601756e-09*sin(ScanAngleTheta)*sin(ScanAnglePhi))) rad
  ScanPhaseShiftB = -((ScanFrequency*1.67667601756e-09*sin(ScanAngleTheta)*cos(ScanAnglePhi)) + (ScanFrequency*0.0*sin(ScanAngleTheta)*sin(ScanAnglePhi))) rad
  ScanMag1 = 1W
  ScanPhase1 = 0deg
  CosinePower = 3
  EdgeTaperLevel_dB = -20
geometry:
  coordinate_system Metal1 = origin=(-subX, -subY, 0cm) Euler Angle ZYZ phi=0deg theta=0deg psi=0deg
  coordinate_system Side = origin=(-subX, -2*subY, 0cm) Euler Angle ZYZ phi=0deg theta=0deg psi=0deg
  coordinate_system Corner = origin=(-2*subX, -2*subY, 0cm) Euler Angle ZYZ phi=0deg theta=0deg psi=0deg
  02_Patch1 = component(02_Patch, 3D_Component_File_Path=D:/Lunch_&_Learn/02_Patch.a3dcomp, subX=subX, subY=subY, InsetDistance=1.46cm, radome_height=1cm, FeedLength=1.5cm, InsetGap=0.168cm, subH=0.1524cm, FeedWidth=0.336cm, patchY=4.39cm, radome_thick=0.8cm)
  sub [Rogers RO4003 (tm)] = part_of(02_Patch1)
  Ground, antenna, port1, Box1 [vacuum] = part_of(02_Patch1)
  Box2 [Teflon (tm)] = part_of(02_Patch1)
  01_Metal_Only1 = component(01_Metal_Only, 3D_Component_File_Path=D:/Lunch_&_Learn/01_Metal_Only.a3dcomp, subX=subX, subY=subY, radome_height=1cm, subH=0.1524cm, patchY=4.39cm, radome_thick=0.8cm)
  sub_1 [Rogers RO4003 (tm)] = part_of(01_Metal_Only1)
  Ground_1, antenna_1, Box1_1 [vacuum] = part_of(01_Metal_Only1)
  Box2_1 [Teflon (tm)] = part_of(01_Metal_Only1)
  03_Radome_Side1 = component(03_Radome_Side, 3D_Component_File_Path=D:/Lunch_&_Learn/03_Radome_Side.a3dcomp, subX=subX, subY=subY, radome_height=1cm, subH=0.1524cm, radome_thick=0.8cm, radius=0.5cm)
  sub_2 [Rogers RO4003 (tm)] = part_of(03_Radome_Side1)
  Ground_2, Box1_2 [vacuum] = part_of(03_Radome_Side1)
  Box2_2, Box4 [Teflon (tm)] = part_of(03_Radome_Side1)
  Radome_Corner1 = component(Radome_Corner, 3D_Component_File_Path=D:/Lunch_&_Learn/03_Radome_Corner.a3dcomp, subX=subX, subY=subY, radome_height=1cm, subH=0.1524cm, radome_thick=0.8cm, radius=0.5cm)
  sub_3 [Rogers RO4003 (tm)] = part_of(Radome_Corner1)
  Ground_3, Box1_3 [vacuum] = part_of(Radome_Corner1)
  Box2_3, Box4_1 [Teflon (tm)] = part_of(Radome_Corner1)
  02_Patch1.move(TranslateVectorX=-0.12 TranslateVectorY=-0.12 TranslateVectorZ=0)
  01_Metal_Only1.move(TranslateVectorX=-0.2 TranslateVectorY=-0.2 TranslateVectorZ=0)
  03_Radome_Side1.move(TranslateVectorX=-0.2 TranslateVectorY=-0.28 TranslateVectorZ=0)
  Radome_Corner1.move(TranslateVectorX=-0.28 TranslateVectorY=-0.28 TranslateVectorZ=0)
boundaries and excitations:
  02_Patch1_antennaMetal: Perfect E Objects=antenna
  02_Patch1_groundMetal: Perfect E Objects=Ground
  02_Patch1_LatticePair1: Lattice Pair Faces=Box1.face(at (-12, -16, 3.4762), at (-12, -8, 3.4762)) CoordSysVector{(-16, -16, 6.9524) -> (-16, -16, 0)} ReverseV PhaseDelay=UseScanAngle Phi=0deg Theta=0deg
  02_Patch1_LatticePair2: Lattice Pair Faces=Box1.face(at (-16, -12, 3.4762), at (-8, -12, 3.4762)) CoordSysVector{(-16, -8, 6.9524) -> (-16, -8, 0)} ReverseV PhaseDelay=UseScanAngle Phi=0deg Theta=0deg
  02_Patch1_Rad1: Radiation Faces=Box1.face(at (-12, -12, 6.9524))
  01_Metal_Only1_groundMetal: Perfect E Objects=Ground_1
  01_Metal_Only1_Antenna: Perfect E Objects=antenna_1
  01_Metal_Only1_Rad1: Radiation Faces=Box1_1.face(at (-20, -20, 6.9524))
  01_Metal_Only1_LatticePair1: Lattice Pair Faces=Box1_1.face(at (-20, -24, 3.4762), at (-20, -16, 3.4762)) CoordSysVector{(-24, -24, 6.9524) -> (-24, -24, 0)} ReverseV PhaseDelay=UseScanAngle Phi=0deg Theta=0deg
  01_Metal_Only1_LatticePair2: Lattice Pair Faces=Box1_1.face(at (-24, -20, 3.4762), at (-16, -20, 3.4762)) CoordSysVector{(-24, -16, 6.9524) -> (-24, -16, 0)} ReverseV PhaseDelay=UseScanAngle Phi=0deg Theta=0deg
  03_Radome_Side1_groundMetal: Perfect E Objects=Ground_2
  03_Radome_Side1_Rad1: Radiation Faces=Box1_2.face(at (-20, -28, 6.9524))
  03_Radome_Side1_LatticePair1: Lattice Pair Faces=Box1_2.face(at (-20, -32, 3.4762), at (-20, -24, 3.4762)) CoordSysVector{(-24, -32, 6.9524) -> (-24, -32, 0)} ReverseV PhaseDelay=UseScanAngle Phi=0deg Theta=0deg
  03_Radome_Side1_LatticePair2: Lattice Pair Faces=Box1_2.face(at (-24, -28, 3.4762), at (-16, -28, 3.4762)) CoordSysVector{(-24, -24, 6.9524) -> (-24, -24, 0)} ReverseV PhaseDelay=UseScanAngle Phi=0deg Theta=0deg
  Radome_Corner1_groundMetal: Perfect E Objects=Ground_3
  Radome_Corner1_Rad1: Radiation Faces=Box1_3.face(at (-28, -28, 6.9524))
  Radome_Corner1_LatticePair1: Lattice Pair Faces=Box1_3.face(at (-28, -32, 3.4762), at (-28, -24, 3.4762)) CoordSysVector{(-32, -32, 6.9524) -> (-32, -32, 0)} ReverseV PhaseDelay=UseScanAngle Phi=0deg Theta=0deg
  Radome_Corner1_LatticePair2: Lattice Pair Faces=Box1_3.face(at (-32, -28, 3.4762), at (-24, -28, 3.4762)) CoordSysVector{(-32, -24, 6.9524) -> (-32, -24, 0)} ReverseV PhaseDelay=UseScanAngle Phi=0deg Theta=0deg
  02_Patch1_1: Lumped Port Faces=port1.face(at (-12, -8.305, 0.0762)) LumpedPortType=Modal Modes{Mode1{IntLine{(-12, -8.305, 0.1524) -> (-12, -8.305, 0)} CharImp=Zpi}} Impedance=50ohm
array:
  Type="3D Component" Name=A1 UseAirObjects RowPrimaryBnd=01_Metal_Only1_LatticePair1 ColumnPrimaryBnd=01_Metal_Only1_LatticePair2 RowDimension=8 ColumnDimension=8 ShowCellNumber RenderType=0 Padding=0 ComponentMap("'4'=982", "'3'=848", "'2'=737", "'1'=599") ReferenceCSID=1
  UseAbove
setups:
  Setup1: HfssDriven Frequency=1.8GHz MaxDeltaS=0.02 MaximumPasses=20 MinimumPasses=1 MinimumConvergedPasses=1 PercentRefinement=30 SkipArraySolveDuringAdaptivePasses BasisOrder=1 PortAccuracy=2 DrivenSolverType="Direct Solver" SaveRadFieldsOnly
    sweep Discrete_Sweep: 0.9GHz to 2.7GHz, 3 points; Type=Discrete SaveFields SaveRadFields
    sweep Interp_Sweep: 0.9GHz to 2.7GHz, 101 points; Type=Interpolating InterpTolerance=0.5 InterpMaxSolns=250 InterpUsePortImped=false PassivityErrorTolerance=0.0001
source amplitudes:
  02_Patch1_1:1: ScanMag1*1 ScanPhase1 + (2*ScanPhaseShiftA + 2*ScanPhaseShiftB)
  02_Patch1_1:2: ScanMag1*1 ScanPhase1 + (2*ScanPhaseShiftA + 3*ScanPhaseShiftB)
  02_Patch1_1:3: ScanMag1*1 ScanPhase1 + (2*ScanPhaseShiftA + 4*ScanPhaseShiftB)
  02_Patch1_1:4: ScanMag1*1 ScanPhase1 + (2*ScanPhaseShiftA + 5*ScanPhaseShiftB)
  02_Patch1_1:5: ScanMag1*1 ScanPhase1 + (3*ScanPhaseShiftA + 2*ScanPhaseShiftB)
  02_Patch1_1:6: ScanMag1*1 ScanPhase1 + (3*ScanPhaseShiftA + 3*ScanPhaseShiftB)
  02_Patch1_1:7: ScanMag1*1 ScanPhase1 + (3*ScanPhaseShiftA + 4*ScanPhaseShiftB)
  02_Patch1_1:8: ScanMag1*1 ScanPhase1 + (3*ScanPhaseShiftA + 5*ScanPhaseShiftB)
  02_Patch1_1:9: 0W ScanPhase1 + (4*ScanPhaseShiftA + 2*ScanPhaseShiftB)
  02_Patch1_1:10: ScanMag1*1 ScanPhase1 + (4*ScanPhaseShiftA + 3*ScanPhaseShiftB)
  02_Patch1_1:11: 0W ScanPhase1 + (4*ScanPhaseShiftA + 4*ScanPhaseShiftB)
  02_Patch1_1:12: ScanMag1*1 ScanPhase1 + (4*ScanPhaseShiftA + 5*ScanPhaseShiftB)
  02_Patch1_1:13: ScanMag1*1 ScanPhase1 + (5*ScanPhaseShiftA + 2*ScanPhaseShiftB)
  02_Patch1_1:14: ScanMag1*1 ScanPhase1 + (5*ScanPhaseShiftA + 3*ScanPhaseShiftB)
  02_Patch1_1:15: ScanMag1*1 ScanPhase1 + (5*ScanPhaseShiftA + 4*ScanPhaseShiftB)
  02_Patch1_1:16: ScanMag1*1 ScanPhase1 + (5*ScanPhaseShiftA + 5*ScanPhaseShiftB)
radiation setups:
  Infinite Sphere1: Infinite Sphere Theta=-180deg..180deg step 2deg Phi=0deg..360deg step 2deg
reports:
  Gain Plot 1: dB(GainTotal) vs Theta on Setup1 : LastAdaptive, Infinite Sphere1 [Phi=0deg Freq=1.8GHz]
  Gain Plot 2: dB(GainTotal) vs Phi, Theta on Setup1 : LastAdaptive, Infinite Sphere1 [Freq=1.8GHz]
