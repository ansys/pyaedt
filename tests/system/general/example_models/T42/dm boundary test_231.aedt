# Ansys Electronics Desktop project, version 2023.1
materials:
  vacuum: permittivity=1
  my_mat_ADK: permittivity=2.2 dielectric_loss_tangent=0.0009
  pec: conductivity=1e+30
  copper: permeability=0.999991 conductivity=58000000
  tungsten: conductivity=18200000

design HFSSDesign1 (HFSS, HFSS Modal Network, model units mm)
variables:
  subH = 62mil
  subX = 7.5cm
  subY = 10.1cm
  dipole_length = 5.03cm
  Port_Gap_Width = 0.13cm
  Antenna_Width = 0.5cm
geometry:
  RadiatingSurface [tungsten] = region(absolute_offset=100mm on all sides)
  sub [my_mat_ADK] = imported_body()
  antenna, antenna_1, port1 [pec] = imported_body()
  Rectangle1 [tungsten] = imported_body()
  Rectangle2 [vacuum] = imported_body()
  Rectangle3 [tungsten] = imported_body()
  Rectangle4..Rectangle7 [vacuum] = imported_body()
  pecCap1 [pec] = imported_body()
boundaries and excitations:
  perfE_BC: Perfect E Objects=[antenna, antenna_1]
  Radiation_BC: Radiation Objects=RadiatingSurface
  FiniteCond_BC: Finite Conductivity Objects=[Rectangle1, Rectangle3] UseMaterial Material=copper Roughness=20um IsInternal
  LumpRLC_BC: Lumped RLC Objects=Rectangle2 CurrentLine{(16, -28, 0) -> (16, -20, 0)} RLC_Type=Parallel Resistance=50ohm
  Impedance_BC: Impedance Objects=Rectangle4 Resistance=50 Reactance=50
  Anisotropic_Impedance_BC: Anisotropic Impedance Objects=Rectangle5 CoordSystem=Global ZxxResistance=377 ZxxReactance=0 ZxyResistance=0 ZxyReactance=0 ZyxResistance=0 ZyxReactance=0 ZyyResistance=377 ZyyReactance=0
  Layered_Impedance_BC: Layered Impedance Objects=Rectangle6 Frequency=0GHz Layers{Layer1{Thickness=1um Material=copper} Layer2{LayerType=1 Thickness=1um Material=vacuum}}
  PerfH1_BC: Perfect H Objects=Rectangle7
  p1: Lumped Port Objects=port1 Modes{Mode1{IntLine{(0, 0.65, 0) -> (0, -0.65, 0)} CharImp=Zpi RenormImp=50ohm}} Impedance=50ohm
  1: Wave Port Faces=?.face(#11) NumModes=5 Modes{Mode1{IntLine{(37.5, 50.5, -1.5748) -> (37.5, 50.5, 0)} CharImp=Zpi} Mode2{IntLine{(37.5, 50.5, 0) -> (28, 50.5, 0)} CharImp=Zpi} Mode3{CharImp=Zpi} Mode4{CharImp=Zpi} Mode5{CharImp=Zpi}}
setups:
  Setup1: HfssDriven Frequency=1GHz MaxDeltaS=0.02 MaximumPasses=6 MinimumPasses=1 MinimumConvergedPasses=1 PercentRefinement=30 BasisOrder=1 PortAccuracy=2 DrivenSolverType="Direct Solver"
    sweep Sweep: 0.5GHz to 1.5GHz, 401 points; Type=Interpolating InterpTolerance=0.5 InterpMaxSolns=250 InterpUsePortImped=false PassivityErrorTolerance=0.0001
source amplitudes:
  p1:1: 1W 0deg
  1:1..1:5: 0W 0deg
radiation setups:
  3D: Infinite Sphere Theta=0deg..180deg step 2deg Phi=-180deg..180deg step 2deg
  Elevation: Infinite Sphere Theta=-180deg..180deg step 1deg Phi=0deg..90deg step 90deg
  Azimuth: Infinite Sphere Theta=90deg..90deg step 0deg Phi=-180deg..180deg step 1deg
