# Ansys Electronics Desktop project, version 2024.2
materials:
  copper: permeability=0.999991 conductivity=58000000
  vacuum: permittivity=1

design 1 maxwell busbar (Maxwell 3D, TransientAPhiFormulation, model units mm)
variables:
  xsize = 50mm
  ysize = 70mm
  zsize = 1mm
  fillet_radius = 1mm
  hole_xpos = 9mm
  hole_ypos = 9mm
  hole_radius = 7mm
  hole_yspacing = 25mm
  hole_xspacing = 25mm
  small_hole_xpos = 21.5mm
  small_hole_xspacing = 25mm
  bar_width = 15mm
  bar_xpos = 14mm
  bar_length = 10mm
  bar_offset = 8mm
  pin_offset = 15mm
  bar_width2 = 16mm
  zdistance = 1mm
  xoffset = 8mm
  small_hole_radius = 2mm
  small_hole_yspacing2 = 25mm
  terminal_yoffset = 25mm
  freq1 = 50Hz
datasets:
  Winding1: (0, 0) (1e-05, 931.05229) (2e-05, 1946.7365) (3e-05, 2970.0962) (4e-05, 3994.126) (5.7181862e-05, 5753.6142) (0.0001302599, 13234.628) (0.0004956501, 50456.174) (0.0010682045, 107262.22) (0.0015740371, 154626.15) (0.0022527989, 211859.55) (0.0026964449, 244227.75) (0.0029718909, 261975.8) (0.0030704611, 267858.23) (0.0031096745, 270126.28) (0.0031261842, 271069.82) (0.0031361842, 271636.99) (0.0031461842, 272201.95) (0.0031561842, 272764.19) (0.0032061842, 275534.35) (0.0032376094, 277242.25) (0.0032476094, 277778.69) (0.0032576094, 278313.6) (0.0032676094, 278845.56) (0.0032903622, 280045.43) (0.003341558, 282693.78) (0.0033703336, 284149.43) (0.003383957, 284831.16) (0.003393957, 285327.64) (0.003403957, 285821.6) (0.003413957, 286312.74) (0.003463957, 288725.44) (0.0034823961, 289598.72) (0.0034923961, 290066.63) (0.0035023961, 290532.84) (0.0035123961, 290995.98) (0.0035346477, 292016.02) (0.0035818903, 294135.27) (0.0036048254, 295139.96) (0.0036149078, 295577.42) (0.0036249078, 296007.71) (0.0036349078, 296435.3) (0.0036449078, 296860) (0.0036949078, 298938.93) (0.0037049078, 299347.2) (0.0037149078, 299750.74) (0.0037249078, 300151.84) (0.0037374647, 300651.32) (0.003800249, 303078.97) (0.0038537559, 305054.23) (0.0038843366, 306144.96) (0.0039019193, 306758.88) (0.0039126603, 307129.65) (0.0039226603, 307471.4) (0.0039326603, 307810.15) (0.0039426603, 308145.94) (0.0039713758, 309093.01) (0.0039912264, 309733.98) (0.0040012264, 310051.34) (0.0040112264, 310366.3) (0.0040212264, 310678.12) (0.0040524943, 311633) (0.0040644451, 311990.95) (0.0040744451, 312285.86) (0.0040844451, 312578.31) (0.0040944451, 312867.61) (0.0041267933, 313781.95) (0.0041367933, 314058.97) (0.0041467933, 314331.63) (0.0041567933, 314601.59) (0.0041686503, 314917.68) (0.0042279349, 316432.98) (0.0042565123, 317123.75) (0.0042683059, 317401.75) (0.0042783059, 317633.68) (0.0042883059, 317862.57) (0.0042983059, 318088.39) (0.0043238354, 318650.44) (0.0043338354, 318865.76) (0.0043438354, 319076.89) (0.0043538354, 319285.23) (0.0043650669, 319515.48) (0.0044198097, 320581.17) (0.0044370181, 320896.2) (0.0044470181, 321075.34) (0.0044570181, 321250.88) (0.0044670181, 321423.45) (0.0044804717, 321650.59) (0.0045088279, 322111.01) (0.0045188279, 322266.84) (0.0045288279, 322419.76) (0.0045388279, 322569.53) (0.0045707268, 323025.67) (0.0045807268, 323162.92) (0.0045907268, 323295.71) (0.0046007268, 323425.71) (0.0046107268, 323552.56) (0.004637913, 323881.01) (0.004647913, 323996.69) (0.004657913, 324108.06) (0.004667913, 324216.6) (0.004677913, 324321.97) (0.0047042032, 324583.48) (0.0047142032, 324677.92) (0.0047242032, 324768.08) (0.0047342032, 324855.38) (0.0047442032, 324939.52) (0.0047681875, 325128.03) (0.0047781875, 325201.89) (0.0047881875, 325271.54) (0.0047981875, 325338.33) (0.0048081875, 325401.93) (0.0048299992, 325529.34) (0.0048399992, 325583.29) (0.0048499992, 325633.11) (0.0048599992, 325680.04) (0.0048699992, 325723.78) (0.0048891696, 325798.51) (0.0048991696, 325833.38) (0.0049091696, 325864.2)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
geometry:
  Busbar1 = box(corner=(0mm, 0mm, 0mm), size=(xsize, ysize, zsize))
  Busbar1.fillet(Edges=Busbar1.edge(at (50, 0, 0.5)) Radius=fillet_radius Setback=0mm)
  Busbar1.fillet(Edges=Busbar1.edge(at (50, 70, 0.5), at (0, 70, 0.5), at (0, 0, 0.5)) Radius=fillet_radius Setback=0mm)
  hole = cylinder(axis=Z, base_centre=(hole_xpos, hole_ypos, 0mm), radius=hole_radius, height=zsize)
  hole_1, hole_2 = hole.duplicate_along_line(step=(0mm, hole_yspacing, 0mm), total=3)
  hole_3 = hole.duplicate_along_line(step=(hole_xspacing, 0mm, 0mm), total=2)
  hole_1_1 = hole_1.duplicate_along_line(step=(hole_xspacing, 0mm, 0mm), total=2)
  hole_2_1 = hole_2.duplicate_along_line(step=(hole_xspacing, 0mm, 0mm), total=2)
  Busbar1.subtract(hole, hole_1, hole_1_1, hole_2, hole_2_1, hole_3)
  hole_small = cylinder(axis=Z, base_centre=(small_hole_xpos, hole_ypos, 0mm), radius=small_hole_radius, height=zsize)
  hole_small_1, hole_small_2 = hole_small.duplicate_along_line(step=(0mm, hole_yspacing, 0mm), total=3)
  hole_small_3 = hole_small.duplicate_along_line(step=(small_hole_xspacing, 0mm, 0mm), total=2)
  hole_small_1_1 = hole_small_1.duplicate_along_line(step=(small_hole_xspacing, 0mm, 0mm), total=2)
  hole_small_2_1 = hole_small_2.duplicate_along_line(step=(small_hole_xspacing, 0mm, 0mm), total=2)
  Busbar1.subtract(hole_small, hole_small_1, hole_small_1_1, hole_small_2, hole_small_2_1, hole_small_3)
  DC_pos = box(corner=(bar_xpos, 0mm, 0mm), size=(bar_width, -bar_offset, zsize))
  Box1 = box(corner=(14mm, -8mm, 1mm), size=(pin_offset, zsize, bar_length))
  DC_pos.unite(Box1)
  DC_pos.fillet(Edges=Busbar1.edge(at (21.5, -8, 0)) Radius=fillet_radius Setback=0mm)
  DC_pos.fillet(Edges=Busbar1.edge(at (21.5, -7, 1)) Radius=fillet_radius Setback=0mm)
  DC_pos.fillet(Edges=Busbar1.edge(at (29, -7.5, 11), at (14, -7.5, 11)) Radius=fillet_radius Setback=0mm)
  Pterminal = box(corner=(0mm, 13.5mm, 0mm), size=(-bar_offset, bar_width2, zsize))
  Box3 = box(corner=(-8mm, 13.5mm, 1mm), size=(zsize, 16mm, bar_length))
  Pterminal.unite(Box3)
  Pterminal.fillet(Edges=Busbar1.edge(at (-8, 21.5, 0), at (-7.5, 29.5, 11), at (-7.5, 13.5, 11), at (-7, 21.5, 1)) Radius=fillet_radius Setback=0mm)
  Busbar1.unite(Pterminal)
  Busbar1.unite(DC_pos)
  pin = cylinder(axis=Z, base_centre=(small_hole_xpos, hole_ypos, 0mm), radius=small_hole_radius, height=2mm)
  pin_1 [copper] = pin.duplicate_along_line(step=(25mm, 0mm, 0mm), total=2)
  pin.delete()
  Region [vacuum] = region(percentage_offset: +X=100, -X=100, +Y=100, -Y=100, +Z=0, -Z=100)
  Busbar1_SweepFaceAlongNormal1 [copper] = sweep_along_normal(Busbar1.face(at (-7.5, 21.5, 11)), length=5mm)
  Busbar1.delete()
  pin_1.move_faces(MoveAlongNormalFlag=true OffsetDistance=14mm FacesToMove=pin_1.face(at (46.5, 9, 16)))
boundaries and excitations:
  FluxTangential1: Flux Tangential Faces=Region.face(all 6)
  CoilTerminal_1: Coil Terminal Faces=pin_1.face(at (46.5, 9, 16)) Conductor_number=1 Winding=Winding1 Point_out_of_terminal=true
  CoilTerminal_2: Coil Terminal Faces=Busbar1_SweepFaceAlongNormal1.face(at (-7.5, 21.5, 16)) Conductor_number=1 Winding=Winding1 Point_out_of_terminal=false
  CoilTerminal1: Coil Terminal Faces=pin_1.face(at (46.5, 9, 16)) Conductor_number=1 Winding=Winding2 Point_out_of_terminal=false
  CoilTerminal2: Coil Terminal Faces=Busbar1_SweepFaceAlongNormal1.face(at (-7.5, 21.5, 16)) Conductor_number=1 Winding=Winding2 Point_out_of_terminal=false
  Winding1: Winding Group Type=Current IsSolid=true Current=pwl(Winding1,Time) ParallelBranchesNum=1 CoilOrderList(4, 5)
  Winding2: Winding Group Type=Current IsSolid=true Current=2mA ParallelBranchesNum=1 CoilOrderList(8)
  eddy effects on: pin_1
mesh:
  initial mesh: GlobalSurfApproximation{CurvedSurfaceApproxChoice=ManualSettings NormalDev=20deg} GlobalCurvilinear{Apply}
setups:
  Setup1: TransientAPhiFormulation NonlinearSolverResidual=0.005 ScalarPotential="Second Order" StopTime=1/freq1 TimeStep="1/freq1/10 *1s" SaveFieldsType="Every N Steps" N_Steps=1 Steps_From=0s Steps_To=1/freq1 NumberSolveSteps=1 RangeStart=0s RangeEnd=0.1s
reports:
  Calculator Expressions Plot 1: busbar_loss vs Time on Setup1 : Transient
  Winding Plot 1: InputCurrent(Winding1) vs Time on Setup1 : Transient

design 2 simplorer circuit (Twin Builder)
components:
  L1 = L(L=0.001uH)
  R1 = R(R=1mOhm)
  E1 = E(Type=ESINE PERIO=0 TPERIO=Tend+1)
nets:
  0: E1.0, L1.1
  net_1: R1.1, L1.0
  net_2: E1.1, R1.0
setups:
  TR: TransientData(40ms, 10.0us, 1.0ms, false, "")
