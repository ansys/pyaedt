# Ansys Electronics Desktop project, version 2023.2
materials:
  vacuum: permittivity=1

design Maxwell3DDesign1 (Maxwell 3D, TransientAPhiFormulation, model units mm)
geometry:
  LC1_1 = component(LC1, Type="Layout Component" Unit=mm EDBDefinition=LayoutForce_Layout_APhi BoundingBoxID=182 BoundingBoxLowPoint(0.069676734, 0.032771156, 0) BoundingBoxHighPoint(0.10068039, 0.067634993, 0.00203454) LayoutDesignComponentData{Port1{Type=Excitations Description="Type=PortBoundary"} Port2{Type=Excitations Description="Type=PortBoundary"} U8{Type=Components Description="Type=IC"} U9{Type=Components Description="Type=IC"} EU1{Type=Components Description="Type=Other"} U1{Type=Components Description="Type=IC"} U3{Type=Components Description="Type=IC"} Q4{Type=Components Description="Type=Other"} J4A3{Type=Components Description="Type=IO"} R1L11{Type=Components Description="Type=Resistor"} R1L11{Type="Circuit Elements" Description="Model Type=RLC network, Enabled=False"} MH4{Type=Components Description="Type=Other"} R2L20{Type=Components Description="Type=Resistor"} R2L20{Type="Circuit Elements" Description="Model Type=RLC network, Enabled=False"} U1L4{Type=Components Description="Type=IC"} U1L3{Type=Components Description="Type=IC"} C3A15{Type=Components Description="Type=Capacitor"} C3A15{Type="Circuit Elements" Description="Model Type=RLC network, Enabled=False"} U1L1{Type=Components Description="Type=IC"} U1L2{Type=Components Description="Type=IC"} J4A2{Type=Components Description="Type=IO"} DS4A2{Type=Components Description="Type=Other"} DS4A1{Type=Components Description="Type=Other"} C3A17{Type=Components Description="Type=Capacitor"} C3A17{Type="Circuit Elements" Description="Mode)
  LC1_Footprint, LC1_Port1_Footprint, LC1_Port2_Footprint, LC1_Port1_T1_Footprint, LC1_Port2_T1_Footprint [non-model] = part_of(LC1_1)
boundaries and excitations:
  LC1_1_Port1: Proxy Port Objects=LC1_Port1_Footprint DefinitionPortName=Port1 PortType="Circuit Port" GroundNodeType="Ideal Ground" VirtualExcitationType=Voltage Voltage=0mV
  LC1_1_Port1_T1: Proxy Terminal Objects=LC1_Port1_T1_Footprint DefinitionPortName=Port1 DefinitionPortTerminalName=T1_Ref
  LC1_1_Port1_T1_Ref: Reference Proxy Terminal DefinitionPortName=Port1
  LC1_1_Port2: Proxy Port Objects=LC1_Port2_Footprint DefinitionPortName=Port2 PortType="Circuit Port" GroundNodeType="Ideal Ground" VirtualExcitationType=Voltage Voltage=0mV
  LC1_1_Port2_T1: Proxy Terminal Objects=LC1_Port2_T1_Footprint DefinitionPortName=Port2 DefinitionPortTerminalName=T1_Ref
  LC1_1_Port2_T1_Ref: Reference Proxy Terminal DefinitionPortName=Port2
mesh:
  initial mesh: GlobalCurvilinear{Apply}
