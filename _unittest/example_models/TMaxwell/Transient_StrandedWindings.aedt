# Ansys Electronics Desktop project, version 2023.1
materials:
  vacuum: permittivity=1
  steel_1008: permeability{HUnit=A_per_meter BUnit=tesla curve (0, 0) (159.2, 0.2402) (318.3, 0.8654) (477.5, 1.1106) (636.6, 1.2458) (795.8, 1.331) (1591.5, 1.5) (3183.1, 1.6) (4774.6, 1.683) (6366.2, 1.741) (7957.7, 1.78) (15915.5, 1.905) (31831, 2.025) (47746.5, 2.085) (63662, 2.13) (79577.5, 2.165) (159155, 2.28) (318310, 2.485) (397887, 2.5851)} conductivity=2000000
  copper: permeability=0.999991 conductivity=58000000

design Maxwell3DDesign2 (Maxwell 3D, Transient, model units mm)
notes: "\	This example is the same as Design1 except using Periodic and Symmetry boundaries.

"\	With a 180deg periodicity, we need to define a Sheet object for the 2 periodic boundaries.  Because the flux repeats exactly, we use the Hd=Hi periodicity condition.

"\	The default boundary condition represents the necessary  Symmetry condition (Odd: Flux Tangential).  We could optionally explicitly assign the Odd Symmetry boundary condition, and that is recommended when using Multiphysics coupling.

"\	Note that it is necessary to use a Symmetry Factor = 4 in this example so that the Voltage source will produce the correct currents (and flux-linkage, back-emf, torque, loss, etc.).  You can find this setting in the menu Maxwell 3D > Design Settings, in the Symmetry Multiplier tab).

"\	We adjust the current excitations by making sure that the cross-section is within the coil volume, and the periodic condition automatically connects conductors that touch the face, and the symmetry condition accounts for the coils being split.
options: Notes='"	This example is the same as Design1 except using Periodic and Symmetry boundaries. / "	With a 180deg periodicity, we need to define a Sheet object for the 2 periodic boundaries.  Because the flux repeats exactly, we use the Hd=Hi periodicity condition. / "	The default boundary condition represents the necessary  Symmetry condition (Odd: Flux Tangential).  We could optionally explicitly assign the Odd Symmetry boundary condition, and that is recommended when using Multiphysics coupling. / "	Note that it is necessary to use a Symmetry Factor = 4 in this example so that the Voltage source will produce the correct currents (and flux-linkage, back-emf, torque, loss, etc.).  You can find this setting in the menu Maxwell 3D > Design Settings, in the Symmetry Multiplier tab). / "	We adjust the current excitations by making sure that the cross-section is within the coil volume, and the periodic condition automatically connects conductors that touch the face, and the symmetry condition accounts for the coils being split.'
geometry:
  Rotor [steel_1008] = user_primitive(RMxprt/SRMCore, DiaGap=70mm, DiaYoke=30mm, Length=65mm, Poles=6, ThkYoke=9mm, Embrace=0.5, Delta=0deg, RFillet=0mm, EndExt=0mm, LenRegion=200mm, InfoCore=0)
  Stator [steel_1008] = user_primitive(RMxprt/SRMCore, DiaGap=75mm, DiaYoke=120mm, Length=65mm, Poles=8, ThkYoke=9mm, Embrace=0.5, Delta=0deg, RFillet=0mm, EndExt=1mm, LenRegion=200mm, InfoCore=1)
  Coil_A1 = Stator.separate_bodies()
  Coil_B1, Coil_C1, Coil_D1, Coil_A2, Coil_B2 [copper] = Coil_A1.duplicate_around_axis(axis=Z, angle=45deg, total=8)  # copies kept: 1..5
  Region [vacuum] = polyhedron(axis=Z, centre=(0mm, 0mm, -100mm), first_corner=(150mm, 0mm, -100mm), sides=12, height=200mm)
  [Rotor, Stator, Coil_A1, Coil_B1, Coil_C1, Coil_D1, Coil_A2, Coil_B2].rotate(axis=Z, angle=22.5deg)
  Rotor.rotate(axis=Z, angle=7.5deg)
  [Rotor, Stator, Coil_A1, Coil_B1, Coil_C1, Coil_D1, Coil_A2, Coil_B2, Region].split(plane=XY, keep=PositiveOnly)
  [Rotor, Stator, Coil_A1].split(plane=YZ, keep=NegativeOnly)
  Coil_A1.delete()
  [Coil_B1, Coil_C1, Coil_D1, Coil_A2, Coil_B2, Region].split(plane=YZ, keep=NegativeOnly)
  PeriodicBC1 = rectangle(corner=(0mm, 0mm, 0mm), y_size=150mm, z_size=100mm)
  PeriodicBC2 = rectangle(corner=(0mm, 0mm, 0mm), y_size=-150mm, z_size=100mm)
  Coil_A2_ObjectFromFace1 [copper] = object_from(Coil_A2.face(at (-21.9629, -38.1195, 0)))
  Coil_D1_ObjectFromFace1 [copper] = object_from(Coil_D1.face(at (-42.4847, -11.4244, 0)))
  Coil_C1_ObjectFromFace1 [copper] = object_from(Coil_C1.face(at (-38.1195, 21.9629, 0)))
  Coil_B1_ObjectFromFace1 [copper] = object_from(Coil_B1.face(at (-11.4244, 42.4847, 0)))
  [Coil_A2_ObjectFromFace1, Coil_D1_ObjectFromFace1, Coil_C1_ObjectFromFace1, Coil_B1_ObjectFromFace1].move(0mm, 0mm, 8.375mm)
  list Facelist1 = Coil_A2.face(at (-38.1195, -21.9629, 0))
boundaries and excitations:
  Independent1: Independent Objects=PeriodicBC1 CoordSysVector{(0, 0, 0) -> (0, 150, 0)} ReverseV
  Dependent1: Dependent Objects=PeriodicBC2 CoordSysVector{(0, 0, 0) -> (0, -150, 0)} ReverseV Independent=Independent1 RelationIsSame=true
  Terminal_A2_1: Coil Terminal Objects=Coil_A2_ObjectFromFace1 Conductor_number=150 Winding=Winding1 Point_out_of_terminal=false
  Terminal_D1_1: Coil Terminal Objects=Coil_D1_ObjectFromFace1 Conductor_number=150 Winding=Winding4 Point_out_of_terminal=false
  Terminal_C1_1: Coil Terminal Objects=Coil_C1_ObjectFromFace1 Conductor_number=150 Winding=Winding3 Point_out_of_terminal=false
  Terminal_B1_1: Coil Terminal Objects=Coil_B1_ObjectFromFace1 Conductor_number=150 Winding=Winding2 Point_out_of_terminal=false
  Winding1: Winding Group Type=Voltage IsSolid=false Current=0A Resistance=2.3ohm Inductance=0mH Voltage=120V ParallelBranchesNum=1
  Winding2: Winding Group Type=Voltage IsSolid=false Current=0A Resistance=2.3ohm Inductance=0mH Voltage=120V ParallelBranchesNum=1
  Winding3: Winding Group Type=Voltage IsSolid=false Current=0A Resistance=2.3ohm Inductance=0mH Voltage=120V ParallelBranchesNum=1
  Winding4: Winding Group Type=Voltage IsSolid=false Current=0A Resistance=2.3ohm Inductance=0mH Voltage=120V ParallelBranchesNum=1
mesh:
  Length1: LengthBased RefineInside Objects=[Coil_A2, Coil_B1, Coil_B2, Coil_C1, Coil_D1] NumMaxElem=4000
  Length2: LengthBased RefineInside Objects=[Rotor, Stator] NumMaxElem=1000
  initial mesh: GlobalCurvilinear{Apply}
setups:
  Setup1: Transient NonlinearSolverResidual=0.005 ScalarPotential="Second Order" StopTime=0.01s TimeStep=0.002s
reports:
  XY Plot 1: Current(Winding1), Current(Winding2), Current(Winding3), Current(Winding4) vs Time on Setup1 : Transient
