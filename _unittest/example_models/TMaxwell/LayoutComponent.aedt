# Ansys Electronics Desktop project, version 2023.2
materials:
  vacuum: permittivity=1

design Maxwell3DDesign1 (Maxwell 3D, TransientAPhiFormulation, model units mm)
geometry:
  LC1_1 = component(LC1, Type="Layout Component" Unit=mm EDBDefinition=ANSYS-HSD_V1 BoundingBoxID=2042 BoundingBoxLowPoint(-0.014260049, -0.0039999996, 0) BoundingBoxHighPoint(0.1495, 0.079699747, 0.001748) LayoutDesignComponentData{C380{Type=Components Description="Type=Capacitor"} C380:_1-2{Type="Circuit Elements" Description="Model Type=RLC network, Enabled=True, Configuration=Series, R disabled, L disabled, C = 10nF"} C379{Type=Components Description="Type=Capacitor"} C379:_1-2{Type="Circuit Elements" Description="Model Type=RLC network, Enabled=True, Configuration=Series, R disabled, L disabled, C = 10nF"} C378{Type=Components Description="Type=Capacitor"} C378:_1-2{Type="Circuit Elements" Description="Model Type=RLC network, Enabled=True, Configuration=Series, R disabled, L disabled, C = 10nF"} C377{Type=Components Description="Type=Capacitor"} C377:_1-2{Type="Circuit Elements" Description="Model Type=RLC network, Enabled=True, Configuration=Series, R disabled, L disabled, C = 10nF"} C376{Type=Components Description="Type=Capacitor"} C376:_1-2{Type="Circuit Elements" Description="Model Type=RLC network, Enabled=True, Configuration=Series, R disabled, L disabled, C = 10nF"} C375{Type=Components Description="Type=Capacitor"} C375:_1-2{Type="Circuit Elements" Description="Model Type=RLC network, Enabled=True, Configuration=Series, R disabled, L disabled, C = 10nF"} C374{Type=Components Description="Type=Capacitor"} C374:_1-2{Type="Circuit Elements" Description="Model Type=RLC network, Enabled=True)
  LC1_Footprint [non-model] = part_of(LC1_1)
mesh:
  initial mesh: GlobalCurvilinear{Apply}
