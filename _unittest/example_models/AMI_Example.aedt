# Ansys Electronics Desktop project, version 2021.1

design Models Init Only (Circuit)
notes: This example demonstrates AMI analysis of a channel, with VerifEye analysis for comparison.

The FFE tap weights are controlled by project variables tx_ffe1, tx_ffe2, tx_ffe3, rx_ffe1, rx_ffe2, and rx_ffe3.

The AMI and VE analyses are set up, as are the reports.

Analyze all, then expand the Results icon to view the plots.


AMI Models (Tx and Rx) configured to demonstrate Init() only mode in this example.
options: SParamCircuitDef IntegrationMethod=FFT Notes="This example demonstrates AMI analysis of a channel, with VerifEye analysis for comparison. / The FFE tap weights are controlled by project variables tx_ffe1, tx_ffe2, tx_ffe3, rx_ffe1, rx_ffe2, and rx_ffe3. / The AMI and VE analyses are set up, as are the reports. / Analyze all, then expand the Results icon to view the plots. / AMI Models (Tx and Rx) configured to demonstrate Init() only mode in this example."
variables:
  tx_ffe1 = 0.85
  tx_ffe2 = -0.13
  tx_ffe3 = -0.02
  rx_ffe1 = 1.2
  rx_ffe2 = -0.1
  rx_ffe3 = 0.05
components:
  R5 = RES_()
  S10 = Model()
  U14 = example_tx_P_example_device_tx_ibis_ami_example_tx_diff(PARAMETERS_FILE=$PROJECTDIR/models/AMI_Example/ibis_ami_example_tx.ami COMPONENT=AMI_SOURCE repeater_type="not a repeater" probe_name=b_input_15 vlow=-0.5 vhigh=0.5 AMI_Version=5.1 Ignore_Bits=4 Max_Init_Aggressors=10 Init_Returns_Impulse=true GetWave_Exists=false method=1 ffe_weight_1=tx_ffe1 ffe_weight_2=tx_ffe2 ffe_weight_3=tx_ffe3 trise=10ps tfall=10ps)
  U15 = example_rx_P_example_device_rx_ibis_ami_example_rx_diff(PARAMETERS_FILE=$PROJECTDIR/models/AMI_Example/ibis_ami_example_rx.ami COMPONENT=AMI_PROBE repeater_type="not a repeater" source_name=b_output4_14 AMI_Version=5.1 Ignore_Bits=4 Max_Init_Aggressors=10 Init_Returns_Impulse=true GetWave_Exists=false method=1 clock_threshold=0.4 ffe_weight_1=rx_ffe1 ffe_weight_2=rx_ffe2 ffe_weight_3=rx_ffe3)
nets:
  0: R5.1
  net_1: S10.0, U14.0
  net_2: S10.1, U14.1
  net_3: S10.3, U15.1
  net_4: S10.2, U15.0
  Out_of_In_Term: R5.0
setups:
  AMIAnalysis: InputType=1 AMIAnalysis(32, false, false)
  VerifEyeAnalysis: AdditionalOptions="tran.tmax=5e-11" VerifEyeAnalysis(false, 1e-9, false, 0, "", true)
reports:
  AMI analysis impulse responses: InitialImpulseResponse<b_input_15.int_ami_rx>, IntermediateImpulseResponse<b_input_15.int_ami_rx>, FinalImpulseResponse<b_input_15.int_ami_rx> vs __InitialTime on AMIAnalysis : AMIAnalysis
  AMI signal after probe (compare with VerifEye): EyeAfterProbe<b_input_15.int_ami_rx> vs __UnitInterval, __Amplitude on AMIAnalysis : AMIAnalysis
  AMI driving PWL with jitter: InitialEye<b_output4_14.int_ami_tx> vs __UnitInterval, __Amplitude on AMIAnalysis : AMIAnalysis
  AMI signal after AMI source: EyeAfterSource<b_output4_14.int_ami_tx> vs __UnitInterval, __Amplitude on AMIAnalysis : AMIAnalysis
  AMI signal after channel: EyeAfterChannel<b_input_15.int_ami_rx> vs __UnitInterval, __Amplitude on AMIAnalysis : AMIAnalysis
  VerifEye contour plot: b_input_15.int_ami_rx.eye_probe<Bit Error Rate> vs __UnitInterval, __Amplitude on VerifEyeAnalysis : VerifEyeAnalysis [__EyeOpening=0]
  VerifEye Eye plot: b_input_15.int_ami_rx.eye_probe vs __UnitInterval, __Amplitude on VerifEyeAnalysis : VerifEyeAnalysis
  VerifEye step response (after AMI processing): Rise<b_input_15.int_ami_rx.eye_probe> vs __InitialTime on VerifEyeAnalysis : VerifEyeAnalysis
  VerifEye Bathtub plot: b_input_15.int_ami_rx.eye_probe<Bit Error Rate> vs __UnitInterval on VerifEyeAnalysis : VerifEyeAnalysis [__EyeOpening=0]
  AMI impulse responses spectral: dB(InitialImpulseResponse<b_input_15.int_ami_rx>), dB(FinalImpulseResponse<b_input_15.int_ami_rx>) vs Spectrum on AMIAnalysis : AMIAnalysis

design Models GetWave Only (Circuit)
notes: This example demonstrates AMI analysis of a channel, with VerifEye analysis for comparison.

The FFE tap weights are controlled by project variables tx_ffe1, tx_ffe2, tx_ffe3, rx_ffe1, rx_ffe2, and rx_ffe3.

The AMI and VE analyses are set up, as are the reports.

Analyze all, then expand the Results icon to view the plots.

AMI Models (Tx and Rx) configured to demonstrate GetWave() only mode in this example.
options: SParamCircuitDef IntegrationMethod=FFT Notes="This example demonstrates AMI analysis of a channel, with VerifEye analysis for comparison. / The FFE tap weights are controlled by project variables tx_ffe1, tx_ffe2, tx_ffe3, rx_ffe1, rx_ffe2, and rx_ffe3. / The AMI and VE analyses are set up, as are the reports. / Analyze all, then expand the Results icon to view the plots. / AMI Models (Tx and Rx) configured to demonstrate GetWave() only mode in this example."
variables:
  tx_ffe1 = 0.85
  tx_ffe2 = -0.13
  tx_ffe3 = -0.02
  rx_ffe1 = 1.2
  rx_ffe2 = -0.1
  rx_ffe3 = 0.05
components:
  R5 = RES_()
  S10 = Model()
  U14 = example_tx_P_example_device_tx_ibis_ami_example_tx_diff(PARAMETERS_FILE=$PROJECTDIR/models/AMI_Example/ibis_ami_example_tx.ami COMPONENT=AMI_SOURCE repeater_type="not a repeater" probe_name=b_input_15 vlow=-0.5 vhigh=0.5 AMI_Version=5.1 Ignore_Bits=4 Max_Init_Aggressors=10 Init_Returns_Impulse=false GetWave_Exists=true method=2 ffe_weight_1=tx_ffe1 ffe_weight_2=tx_ffe2 ffe_weight_3=tx_ffe3 trise=10ps tfall=10ps)
  U15 = example_rx_P_example_device_rx_ibis_ami_example_rx_diff(PARAMETERS_FILE=$PROJECTDIR/models/AMI_Example/ibis_ami_example_rx.ami COMPONENT=AMI_PROBE repeater_type="not a repeater" source_name=b_output4_14 AMI_Version=5.1 Ignore_Bits=4 Max_Init_Aggressors=10 Init_Returns_Impulse=false GetWave_Exists=true method=2 clock_threshold=0.4 ffe_weight_1=rx_ffe1 ffe_weight_2=rx_ffe2 ffe_weight_3=rx_ffe3)
nets:
  0: R5.1
  net_1: S10.0, U14.0
  net_2: S10.1, U14.1
  net_3: S10.3, U15.1
  net_4: S10.2, U15.0
  Out_of_In_Term: R5.0
setups:
  AMIAnalysis: InputType=1 AMIAnalysis(32, false, false)
reports:
  AMI analysis impulse responses: InitialImpulseResponse<b_input_15.int_ami_rx>, IntermediateImpulseResponse<b_input_15.int_ami_rx>, FinalImpulseResponse<b_input_15.int_ami_rx> vs __InitialTime on AMIAnalysis : AMIAnalysis
  AMI signal after probe: EyeAfterProbe<b_input_15.int_ami_rx> vs __UnitInterval, __Amplitude on AMIAnalysis : AMIAnalysis
  AMI driving PWL with jitter: InitialEye<b_output4_14.int_ami_tx> vs __UnitInterval, __Amplitude on AMIAnalysis : AMIAnalysis
  AMI signal after AMI source: EyeAfterSource<b_output4_14.int_ami_tx> vs __UnitInterval, __Amplitude on AMIAnalysis : AMIAnalysis
  AMI signal after channel: EyeAfterChannel<b_input_15.int_ami_rx> vs __UnitInterval, __Amplitude on AMIAnalysis : AMIAnalysis
  AMI impulse responses spectral: dB(InitialImpulseResponse<b_input_15.int_ami_rx>), dB(FinalImpulseResponse<b_input_15.int_ami_rx>) vs Spectrum on AMIAnalysis : AMIAnalysis
