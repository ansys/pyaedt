# Ansys Electronics Desktop project, version 2023.1
project variables:
  $height = 10mm
  $dim = 5mm
project datasets:
  $my_materialconductivityTH0: (22, 1) (80, 0.8)
  $AluminumpermittivityTH0: (22, 1) (200, 0.6) (400, 0.39)
  $AluminumconductivityTH0: (22, 1) (200, 0.6) (400, 0.39)
  $AluminumconductivityFM0: (1000000000, 38000000) (2000000000, 38000000) (3000000000, 38000000)
materials:
  vacuum: permittivity=1
  my_material: thermal_modifier{Property=conductivity free_form_value=pwl($my_materialconductivityTH0,Temp)} permittivity=1 permeability=1 conductivity=650000000
  Aluminum: thermal_modifier{Property=permittivity free_form_value=pwl($AluminumpermittivityTH0,Temp)} thermal_modifier{Property=conductivity free_form_value=pwl($AluminumconductivityTH0,Temp)} permittivity{anisotropic component1=1 component2=1 component3=1} permeability=1.000021 conductivity=pwl($AluminumconductivityFM0,Freq)
  teflon_based: permittivity=2.08 dielectric_loss_tangent=0.001

design HFSSDesign (HFSS, HFSS Modal Network, model units mm)
options: Save_Adaptive_support_files
variables:
  height = 5mm
  dim = 5mm
geometry:
  inner [Aluminum] = imported_body()
  Core [teflon_based] = imported_body()
  outer [Aluminum] = imported_body()
  port2, port1 [vacuum] = imported_body()
mesh:
  ModelResolution1: DefeatureBased Objects=[inner, outer] auto length
  Length2: LengthBased Faces=?.face(#59, #16, #17, #18) NumMaxElem=2000 MaxLength=1mm
  initial mesh: GlobalSurfApproximation{CurvedSurfaceApproxChoice=UseSlider SliderMeshSettings=6}
