# Ansys Electronics Desktop project, version 2021.1
project datasets:
  $ds1: (22, 1) (200, 0.6)
materials:
  COPPER: thermal_modifier{Property=conductivity free_form_value=pwl($ds1,Temp)} conductivity=59590000 thermal_conductivity=387.6 mass_density=8933 specific_heat=397
  COPPER_1: conductivity=59590000 thermal_conductivity=387.6 mass_density=8933 specific_heat=397
  FR-4: permittivity=3.86 permeability=1 dielectric_loss_tangent=0.024 thermal_conductivity=0.35 mass_density=1250 specific_heat=1300
  FR-4_1: permittivity=4.5 permeability=1 dielectric_loss_tangent=0.035 thermal_conductivity=0.35 mass_density=1250 specific_heat=1300
  FR-4_2: permittivity=4.34 permeability=1 dielectric_loss_tangent=0.018 thermal_conductivity=0.35 mass_density=1250 specific_heat=1300
  FR-4_3: permittivity=3.86 permeability=1 dielectric_loss_tangent=0.024 thermal_conductivity=0.35 mass_density=1250 specific_heat=1300
  Teflon (tm): permittivity=2.1 dielectric_loss_tangent=0.001 thermal_conductivity=0.25 mass_density=2250 specific_heat=1400 youngs_modulus=496000000 poissons_ratio=0.3 thermal_expansion_coefficient=1.35e-06
  AIR: permittivity=1 permeability=1 thermal_conductivity=0.0261 mass_density=1.1614 specific_heat=1005 thermal_expansion_coefficient=0.00333 thermal_material_type=Fluid diffusivity=2.88e-05 molecular_mass=0.028966 viscosity=1.84e-05
  vacuum: permittivity=1
  Al-Extruded: thermal_conductivity=205 mass_density=2800 specific_heat=900 thermal_material_type=Solid
surface materials:
  Steel-oxidised-surface: surface_emissivity=0.8

design IcepakDesign1 (Icepak, SteadyState TemperatureAndFlow, model units mm)
options: Default_Fluid_Material=air Default_Solid_Material=Al-Extruded Default_Surface_Material=Steel-oxidised-surface AmbientTemperature=amb AmbientPressure=0n_per_meter_sq AmbientRadiationTemperature=amb Gravity_Vector_CS_ID=Global Gravity_Vector_Axis=Z Positive=true
variables:
  amb = 25deg
geometry:
  Region [air] = region(percentage_offset=50 on all sides)
  coordinate_system RelativeCS1 = origin=(-1.71mm, -3.55mm, -15.47912mm) x=(1mm, 0mm, 0mm) y=(0mm, 1mm, 0mm)
  coordinate_system RelativeCS3 = origin=(-1.71mm, -3.55mm, -15.47912mm) x=(1mm, 0mm, 0mm) y=(0mm, 1mm, 0mm)
  coordinate_system RelativeCS2 = origin=(-1.71mm, -3.55mm, -15.47912mm) x=(1mm, 0mm, 0mm) y=(0mm, 1mm, 0mm)
  coordinate_system RelativeCS4 = origin=(-1.71mm, -3.55mm, -15.47912mm) x=(1mm, 0mm, 0mm) y=(0mm, 1mm, 0mm)
  coordinate_system RelativeCS5 = origin=(-1.71mm, -3.55mm, -15.47912mm) x=(1mm, 0mm, 0mm) y=(0mm, 1mm, 0mm)
  coordinate_system RelativeCS6 = origin=(-1.71mm, -3.55mm, -15.47912mm) x=(1mm, 0mm, 0mm) y=(0mm, 1mm, 0mm)
  coordinate_system RelativeCS7 = origin=(-1.71mm, -3.55mm, -15.47912mm) x=(1mm, 0mm, 0mm) y=(0mm, 1mm, 0mm)
  coordinate_system RelativeCS8 = origin=(-1.71mm, -3.55mm, -15.47912mm) x=(1mm, 0mm, 0mm) y=(0mm, 1mm, 0mm)
  coordinate_system RelativeCS9 = origin=(-1.71mm, -3.55mm, -15.47912mm) x=(1mm, 0mm, 0mm) y=(0mm, 1mm, 0mm)
  RadioBoard1_1 = component(RadioBoard1, Type=PCB Unit=mm MovePlane=XY ExtentsType="Bounding Box" PartsChoice=0 EDB_Directory=C:\Users\jleonatt\AppData\Local\Temp\scratchWNF7AH\Filter_Board.aedb\ BBoxPolygon("cw=false", "cl=true", "pt(U='mm', x=33.5644, y=-3.80782, x=59.3228, y=-3.80782, x=59.3228, y=40.3217, x=33.5644, y=40.3217, x=33.5644, y=-3.80782)") EdbLayerInfoMap{oneLayerInfo{LayerIndex=1 LayerName=TOP LayerMaterial=COPPER Thickness=1.9mil LayerLowerElevation=0.00198628 LayerType=0 3D_Layout_Model_Unit=36} oneLayerInfo{LayerIndex=2 LayerName=UNNAMED_002 LayerMaterial=FR-4_3 Thickness=2.65mil LayerLowerElevation=0.00191897 LayerType=1 3D_Layout_Model_Unit=36} oneLayerInfo{LayerIndex=3 LayerName=PWR LayerMaterial=COPPER_1 Thickness=1.3mil LayerLowerElevation=0.00188595 LayerType=0 3D_Layout_Model_Unit=36} oneLayerInfo{LayerIndex=4 LayerName=UNNAMED_004 LayerMaterial=FR-4_2 Thickness=50mil LayerLowerElevation=0.00061595 LayerType=1 3D_Layout_Model_Unit=36} oneLayerInfo{LayerIndex=5 LayerName=LYR_1 LayerMaterial=COPPER_1 Thickness=1.2mil LayerLowerElevation=0.00058547 LayerType=0 3D_Layout_Model_Unit=36} oneLayerInfo{LayerIndex=6 LayerName=UNNAMED_006 LayerMaterial=FR-4_1 Thickness=8mil LayerLowerElevation=0.00038227 LayerType=1 3D_Layout_Model_Unit=36} oneLayerInfo{LayerIndex=7 LayerName=LYR_2 LayerMaterial=COPPER_1 Thickness=1.2mil LayerLowerElevation=0.00035179 LayerType=0 3D_Layout_Model_Unit=36} oneLayerInfo{LayerIndex=8 LayerName=UNNAMED_008 LayerMaterial=FR-4_1 Thickness=8mil LayerLowerElevation=0.0001485)
  RadioBoard1_011_BOTTOM_BBox, RadioBoard1_001_TOP_BBox [COPPER, surface Steel-Oxidised-surface] = part_of(RadioBoard1_1)
  RadioBoard1_002_UNNAMED_002_BBox [FR-4_3, surface Steel-Oxidised-surface] = part_of(RadioBoard1_1)
  RadioBoard1_003_PWR_BBox [COPPER_1, surface Steel-Oxidised-surface] = part_of(RadioBoard1_1)
  RadioBoard1_004_UNNAMED_004_BBox [FR-4_2, surface Steel-Oxidised-surface] = part_of(RadioBoard1_1)
  RadioBoard1_005_LYR_1_BBox [COPPER_1, surface Steel-Oxidised-surface] = part_of(RadioBoard1_1)
  RadioBoard1_006_UNNAMED_006_BBox [FR-4_1, surface Steel-Oxidised-surface] = part_of(RadioBoard1_1)
  RadioBoard1_007_LYR_2_BBox [COPPER_1, surface Steel-Oxidised-surface] = part_of(RadioBoard1_1)
  RadioBoard1_008_UNNAMED_008_BBox [FR-4_1, surface Steel-Oxidised-surface] = part_of(RadioBoard1_1)
  RadioBoard1_009_GND_BBox [COPPER_1, surface Steel-Oxidised-surface] = part_of(RadioBoard1_1)
  RadioBoard1_010_UNNAMED_010_BBox [FR-4, surface Steel-Oxidised-surface] = part_of(RadioBoard1_1)
  Component_Region [air, non-model] = box(corner=(33.5644mm, -3.80782mm, 0mm), size=(25.7584mm, 44.12952mm, 2.03454mm))
  USB_VCC [COPPER] = imported_body(D:\_AEs\_Robert\MicroUSB\u_USB_n_PCB.sab)
  coordinate_system RelativeCS10 = origin=(-1.71mm, -3.55mm, -15.47912mm) x=(1mm, 0mm, 0mm) y=(0mm, 1mm, 0mm)
  USB_VCC.split(plane=XY, keep=PositiveOnly) in RelativeCS10
  USB_VCC.rotate(axis=Y, angle=90deg) in RelativeCS10
  USB_VCC.rotate(axis=Y, angle=180deg)
  USB_VCC.rotate(axis=Z, angle=90deg)
  USB_VCC.move(49.318575mm, -5.6356908mm, -12.99458mm)
  USB_VCC.move(0mm, 5mm, 0mm)
  USB_VCC.move(-3.492136mm, -0.93699965mm, -0.34826mm)
  USB_ID [COPPER] = imported_body(D:\_AEs\_Robert\MicroUSB\u_USB_n_PCB.sab)
  USB_ID.split(plane=XY, keep=PositiveOnly) in RelativeCS10
  USB_ID.rotate(axis=Y, angle=90deg) in RelativeCS10
  USB_ID.rotate(axis=Y, angle=180deg)
  USB_ID.rotate(axis=Z, angle=90deg)
  USB_ID.move(49.318575mm, -5.6356908mm, -12.99458mm)
  USB_ID.move(0mm, 5mm, 0mm)
  USB_ID.move(-3.492136mm, -0.93699965mm, -0.34826mm)
  USB_GND [COPPER] = imported_body(D:\_AEs\_Robert\MicroUSB\u_USB_n_PCB.sab)
  USB_GND.split(plane=XY, keep=PositiveOnly) in RelativeCS10
  USB_GND.rotate(axis=Y, angle=90deg) in RelativeCS10
  USB_GND.rotate(axis=Y, angle=180deg)
  USB_GND.rotate(axis=Z, angle=90deg)
  USB_GND.move(49.318575mm, -5.6356908mm, -12.99458mm)
  USB_GND.move(0mm, 5mm, 0mm)
  USB_GND.move(-3.492136mm, -0.93699965mm, -0.34826mm)
  usb_N [COPPER] = imported_body(D:\_AEs\_Robert\MicroUSB\u_USB_n_PCB.sab)
  usb_N.split(plane=XY, keep=PositiveOnly) in RelativeCS10
  usb_N.rotate(axis=Y, angle=90deg) in RelativeCS10
  usb_N.rotate(axis=Y, angle=180deg)
  usb_N.rotate(axis=Z, angle=90deg)
  usb_N.move(49.318575mm, -5.6356908mm, -12.99458mm)
  usb_N.move(0mm, 5mm, 0mm)
  usb_N.move(-3.492136mm, -0.93699965mm, -0.34826mm)
  usb_P [COPPER] = imported_body(D:\_AEs\_Robert\MicroUSB\u_USB_n_PCB.sab)
  usb_P.split(plane=XY, keep=PositiveOnly) in RelativeCS10
  usb_P.rotate(axis=Y, angle=90deg) in RelativeCS10
  usb_P.rotate(axis=Y, angle=180deg)
  usb_P.rotate(axis=Z, angle=90deg)
  usb_P.move(49.318575mm, -5.6356908mm, -12.99458mm)
  usb_P.move(0mm, 5mm, 0mm)
  usb_P.move(-3.492136mm, -0.93699965mm, -0.34826mm)
  USB_Shiels [COPPER] = imported_body(D:\_AEs\_Robert\MicroUSB\u_USB_n_PCB.sab)
  USB_Shiels.rotate(axis=Y, angle=90deg) in RelativeCS10
  USB_Shiels.rotate(axis=Y, angle=180deg)
  USB_Shiels.rotate(axis=Z, angle=90deg)
  USB_Shiels.move(49.318575mm, -5.6356908mm, -12.99458mm)
  USB_Shiels.move(0mm, 5mm, 0mm)
  USB_Shiels.move(-3.492136mm, -0.93699965mm, -0.34826mm)
  USBmale_ObjectFromFace1 [Teflon (tm)] = imported_body(D:\_AEs\_Robert\MicroUSB\u_USB_n_PCB.sab)
  USBmale_ObjectFromFace1.rotate(axis=Y, angle=90deg) in RelativeCS10
  USBmale_ObjectFromFace1.rotate(axis=Y, angle=180deg)
  USBmale_ObjectFromFace1.rotate(axis=Z, angle=90deg)
  USBmale_ObjectFromFace1.move(49.318575mm, -5.6356908mm, -12.99458mm)
  USBmale_ObjectFromFace1.move(0mm, 5mm, 0mm)
  USBmale_ObjectFromFace1.move(-3.492136mm, -0.93699965mm, -0.34826mm)
  Rectangle1 = rectangle(corner=(0mm, -0.125mm, -0.30555841mm), x_size=-0.3mm, y_size=0.25mm)
  Rectangle1_1..Rectangle1_4 = Rectangle1.duplicate_along_line(step=(0mm, 0.65mm, 0mm), total=5)
  Rectangle1.move(0mm, 0mm, 0.1527792mm)
  Rectangle1.move(-1.86mm, -4.975mm, -15.173562mm)
  Rectangle1.rotate(axis=Y, angle=90deg) in RelativeCS10
  Rectangle1.rotate(axis=Y, angle=180deg)
  Rectangle1.rotate(axis=Z, angle=90deg)
  Rectangle1.move(49.318575mm, -5.6356908mm, -12.99458mm)
  Rectangle1.move(0mm, 5mm, 0mm)
  Rectangle1.move(-3.492136mm, -0.93699965mm, -0.34826mm)
  Rectangle1_1.move(0mm, 0mm, 0.1527792mm)
  Rectangle1_1.move(-1.86mm, -4.975mm, -15.173562mm)
  Rectangle1_1.rotate(axis=Y, angle=90deg) in RelativeCS10
  Rectangle1_1.rotate(axis=Y, angle=180deg)
  Rectangle1_1.rotate(axis=Z, angle=90deg)
  Rectangle1_1.move(49.318575mm, -5.6356908mm, -12.99458mm)
  Rectangle1_1.move(0mm, 5mm, 0mm)
  Rectangle1_1.move(-3.492136mm, -0.93699965mm, -0.34826mm)
  Rectangle1_2.move(0mm, 0mm, 0.1527792mm)
  Rectangle1_2.move(-1.86mm, -4.975mm, -15.173562mm)
  Rectangle1_2.rotate(axis=Y, angle=90deg) in RelativeCS10
  Rectangle1_2.rotate(axis=Y, angle=180deg)
  Rectangle1_2.rotate(axis=Z, angle=90deg)
  Rectangle1_2.move(49.318575mm, -5.6356908mm, -12.99458mm)
  Rectangle1_2.move(0mm, 5mm, 0mm)
  Rectangle1_2.move(-3.492136mm, -0.93699965mm, -0.34826mm)
  Rectangle1_3.move(0mm, 0mm, 0.1527792mm)
  Rectangle1_3.move(-1.86mm, -4.975mm, -15.173562mm)
  Rectangle1_3.rotate(axis=Y, angle=90deg) in RelativeCS10
  Rectangle1_3.rotate(axis=Y, angle=180deg)
  Rectangle1_3.rotate(axis=Z, angle=90deg)
  Rectangle1_3.move(49.318575mm, -5.6356908mm, -12.99458mm)
  Rectangle1_3.move(0mm, 5mm, 0mm)
  Rectangle1_3.move(-3.492136mm, -0.93699965mm, -0.34826mm)
  Rectangle1_4.move(0mm, 0mm, 0.1527792mm)
  Rectangle1_4.move(-1.86mm, -4.975mm, -15.173562mm)
  Rectangle1_4.rotate(axis=Y, angle=90deg) in RelativeCS10
  Rectangle1_4.rotate(axis=Y, angle=180deg)
  Rectangle1_4.rotate(axis=Z, angle=90deg)
  Rectangle1_4.move(49.318575mm, -5.6356908mm, -12.99458mm)
  Rectangle1_4.move(0mm, 5mm, 0mm)
  Rectangle1_4.move(-3.492136mm, -0.93699965mm, -0.34826mm)
  Rectangle2 = rectangle(corner=(-0.3mm, -0.125mm, -0.25555841mm), y_size=2.85mm, z_size=-0.1mm)
  Rectangle2.move(0mm, 0mm, 0.1527792mm)
  Rectangle2.move(-1.86mm, -4.975mm, -15.173562mm)
  Rectangle2.rotate(axis=Y, angle=90deg) in RelativeCS10
  Rectangle2.rotate(axis=Y, angle=180deg)
  Rectangle2.rotate(axis=Z, angle=90deg)
  Rectangle2.move(49.318575mm, -5.6356908mm, -12.99458mm)
  Rectangle2.move(0mm, 5mm, 0mm)
  Rectangle2.move(-3.492136mm, -0.93699965mm, -0.34826mm)
  Rectangle3 = rectangle(corner=(1.42mm, 1.5mm, 3.4291458mm), x_size=0.715mm, y_size=-0.4mm)
  Rectangle3_1 = Rectangle3.duplicate_along_line(step=(0mm, -0.65mm, 0mm), total=2)
  Rectangle3.delete()
  Rectangle3_1_1 = Rectangle3_1.duplicate_along_line(step=(0mm, -0.65mm, 0mm), total=2)
  Rectangle3_1_2 = Rectangle3_1.duplicate_along_line(step=(0mm, 1.3mm, 0mm), total=2)
  Rectangle3_1_3 = Rectangle3_1.duplicate_along_line(step=(0mm, 1.95mm, 0mm), total=2)
  Rectangle3_1.move(-1.86mm, -4.975mm, -15.173562mm)
  Rectangle3_1.rotate(axis=Y, angle=90deg) in RelativeCS10
  Rectangle3_1.rotate(axis=Y, angle=180deg)
  Rectangle3_1.rotate(axis=Z, angle=90deg)
  Rectangle3_1.move(49.318575mm, -5.6356908mm, -12.99458mm)
  Rectangle3_1.move(0mm, 5mm, 0mm)
  Rectangle3_1.move(-3.492136mm, -0.93699965mm, -0.34826mm)
  Rectangle3_1_1.move(-1.86mm, -4.975mm, -15.173562mm)
  Rectangle3_1_1.rotate(axis=Y, angle=90deg) in RelativeCS10
  Rectangle3_1_1.rotate(axis=Y, angle=180deg)
  Rectangle3_1_1.rotate(axis=Z, angle=90deg)
  Rectangle3_1_1.move(49.318575mm, -5.6356908mm, -12.99458mm)
  Rectangle3_1_1.move(0mm, 5mm, 0mm)
  Rectangle3_1_1.move(-3.492136mm, -0.93699965mm, -0.34826mm)
  Rectangle3_1_2.move(-1.86mm, -4.975mm, -15.173562mm)
  Rectangle3_1_2.rotate(axis=Y, angle=90deg) in RelativeCS10
  Rectangle3_1_2.rotate(axis=Y, angle=180deg)
  Rectangle3_1_2.rotate(axis=Z, angle=90deg)
  Rectangle3_1_2.move(49.318575mm, -5.6356908mm, -12.99458mm)
  Rectangle3_1_2.move(0mm, 5mm, 0mm)
  Rectangle3_1_2.move(-3.492136mm, -0.93699965mm, -0.34826mm)
  Rectangle3_1_3.move(-1.86mm, -4.975mm, -15.173562mm)
  Rectangle3_1_3.rotate(axis=Y, angle=90deg) in RelativeCS10
  Rectangle3_1_3.rotate(axis=Y, angle=180deg)
  Rectangle3_1_3.rotate(axis=Z, angle=90deg)
  Rectangle3_1_3.move(49.318575mm, -5.6356908mm, -12.99458mm)
  Rectangle3_1_3.move(0mm, 5mm, 0mm)
  Rectangle3_1_3.move(-3.492136mm, -0.93699965mm, -0.34826mm)
  Rectangle4 = rectangle(corner=(-0.3mm, -0.125mm, -0.2027792mm), y_size=-0.53964466mm, z_size=0.1mm)
  Rectangle4.move(-1.86mm, -4.975mm, -15.173562mm)
  Rectangle4.rotate(axis=Y, angle=90deg) in RelativeCS10
  Rectangle4.rotate(axis=Y, angle=180deg)
  Rectangle4.rotate(axis=Z, angle=90deg)
  Rectangle4.move(49.318575mm, -5.6356908mm, -12.99458mm)
  Rectangle4.move(0mm, 5mm, 0mm)
  Rectangle4.move(-3.492136mm, -0.93699965mm, -0.34826mm)
  Rectangle5 = rectangle(corner=(-0.3mm, 2.725mm, -0.2027792mm), y_size=0.53964466mm, z_size=0.1mm)
  Rectangle5.move(-1.86mm, -4.975mm, -15.173562mm)
  Rectangle5.rotate(axis=Y, angle=90deg) in RelativeCS10
  Rectangle5.rotate(axis=Y, angle=180deg)
  Rectangle5.rotate(axis=Z, angle=90deg)
  Rectangle5.move(49.318575mm, -5.6356908mm, -12.99458mm)
  Rectangle5.move(0mm, 5mm, 0mm)
  Rectangle5.move(-3.492136mm, -0.93699965mm, -0.34826mm)
  Rectangle6 = rectangle(corner=(-0.3mm, 3.2646447mm, -0.2027792mm), z_size=0.1mm, x_size=0.335mm)
  Rectangle6.move(-1.86mm, -4.975mm, -15.173562mm)
  Rectangle6.rotate(axis=Y, angle=90deg) in RelativeCS10
  Rectangle6.rotate(axis=Y, angle=180deg)
  Rectangle6.rotate(axis=Z, angle=90deg)
  Rectangle6.move(49.318575mm, -5.6356908mm, -12.99458mm)
  Rectangle6.move(0mm, 5mm, 0mm)
  Rectangle6.move(-3.492136mm, -0.93699965mm, -0.34826mm)
  Rectangle7 = rectangle(corner=(-0.3mm, -0.66464466mm, -0.2027792mm), z_size=0.1mm, x_size=0.335mm)
  Rectangle7.move(-1.86mm, -4.975mm, -15.173562mm)
  Rectangle7.rotate(axis=Y, angle=90deg) in RelativeCS10
  Rectangle7.rotate(axis=Y, angle=180deg)
  Rectangle7.rotate(axis=Z, angle=90deg)
  Rectangle7.move(49.318575mm, -5.6356908mm, -12.99458mm)
  Rectangle7.move(0mm, 5mm, 0mm)
  Rectangle7.move(-3.492136mm, -0.93699965mm, -0.34826mm)
  point P1 = (59mm, 40mm, 0mm)
  Box1 [non-model] = box(corner=(20.6852mm, -28.173566mm, -2.305005335mm), size=(51.5168mm, 91.327021mm, 9.2200213mm))
  group Group1 = USB_VCC, USB_ID, USB_GND, usb_N, usb_P, USB_Shiels, USBmale_ObjectFromFace1, Rectangle1, Rectangle1_1..Rectangle1_4, Rectangle2, Rectangle3_1, Rectangle3_1_1, Rectangle3_1_2, Rectangle3_1_3, Rectangle4..Rectangle7
boundaries and excitations:
  Opening1: Opening Faces=Region.face(all 6) Temperature=AmbientTemp External_Rad._Temperature=AmbientRadTemp Inlet_Type=Pressure Total_Pressure=AmbientPressure
  EMLoss_DRA9XA: EM Loss Objects=[USB_VCC, USB_ID, USB_GND, usb_N, usb_P, USB_Shiels, USBmale_ObjectFromFace1, Rectangle1, Rectangle1_1..Rectangle1_4, Rectangle2, Rectangle3_1, Rectangle3_1_1, Rectangle3_1_2, Rectangle3_1_3, Rectangle4..Rectangle7] LinkID=18 Project=C:\Users\jleonatt\AppData\Local\Temp\scratchWNF7AH\USB_Connector.aedt Design=uUSB ForceSourceToSolve PreservePartnerSoln PathRelativeTo=TargetProject Intrinsics(2.5GHz) SurfaceOnly(32417, 32711, 32873, 34155, 34377, 34599, 36531, 36552, 36571, 36590, 36609, 36628, 36648, 36669, 36687, 36705, 36723, 36742, 36761, 36780) LossMultiplier=1
mesh:
  MeshRegions:  Global{MeshMethod=MesherHD UserSpecifiedSettings ComputeGap MaxElementSizeX=0.42930667mm MaxElementSizeY=0.735492mm MaxElementSizeZ=0.101727mm MinElementsInGap=1 MinElementsOnEdge=1 MaxSizeRatio=2 EnableMLM EnforeMLMType=3D MaxLevels=0 BufferLayers=0 UniformMeshParametersType=Average MinGapX=0.042930667mm MinGapY=0.042930667mm MinGapZ=0.042930667mm Objects=Region FacetLevel=3 ProximitySizeFunction CurvatureSizeFunction} PCB_Region{MeshMethod=MesherHD UserSpecifiedSettings MaxElementSizeX=2mm MaxElementSizeY=2mm MaxElementSizeZ=0.5mm MinElementsInGap=3 MinElementsOnEdge=2 MaxSizeRatio=2 EnableMLM EnforeMLMType=3D MaxLevels=0 BufferLayers=0 UniformMeshParametersType=Average 2DMLMType=2DMLM_None MinGapX=1mm MinGapY=1mm MinGapZ=1mm Objects=Component_Region ProximitySizeFunction CurvatureSizeFunction} MeshRegion_NAWHVC{MeshMethod=MesherHD MeshRegionResolution=3 MinGapX=1mm MinGapY=1mm MinGapZ=1mm Objects=Box1 ProximitySizeFunction CurvatureSizeFunction}
  MeshOperations:  Icepak_E2EBCF_L_2{MaxLevel=2 MinLevel=2 Objects=USB_Shiels Local_Mesh_Parameters_Type="CAD Local Mesh Parameters" X_count=0 Y_count=0 Z_count=0 Facet_Level=0} MeshLevel_MYVM8Z{MaxLevel=2 MinLevel=2 Groups(32415) Local_Mesh_Parameters_Type="No Local Mesh Parameters"}
monitors:
  P1: Quantities(19) Points=#36815
setups:
  DomSetup: IcepakSteadyState Flow_Regime=Laminar Include_Temperature=true Include_Flow=true Convergence_Criteria_-_Flow=0.001 Convergence_Criteria_-_Energy=1e-07 disabled Radiation_Model=Off Under-relaxation_-_Pressure=0.7 Under-relaxation_-_Momentum=0.3 Under-relaxation_-_Temperature=1 Discretization_Scheme_-_Pressure=Standard Discretization_Scheme_-_Momentum=First Discretization_Scheme_-_Temperature=Second 2WayCoupling{NumCouplingIters=2 ContinueIcepakIterations IcepakIterationsPerCoupling=20} Convergence_Criteria_-_Max_Iterations=10
