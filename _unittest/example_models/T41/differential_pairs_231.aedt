# Ansys Electronics Desktop project, version 2023.1
materials:
  copper: permeability=0.999991 conductivity=58000000
  FR4: permittivity=4.35 dielectric_loss_tangent=0.02
  FR4_epoxy: permittivity=4.4 dielectric_loss_tangent=0.02
  pec: conductivity=1e+30
  vacuum: permittivity=1

design Hfss_Terminal (HFSS, HFSS Terminal Network, model units mm)
options: Allow_Material_Override Save_Adaptive_support_files
geometry:
  outer, left, right, port1_sheet, port2_sheet [pec] = imported_body()
  group body = outer, left, right, port1_sheet, port2_sheet
boundaries and excitations:
  P1_T1: Terminal port=P1 Faces=?.face(#120) TerminalResistance=50ohm
  P1_T2: Terminal port=P1 Faces=?.face(#172) TerminalResistance=50ohm
  P2_T1: Terminal port=P2 Faces=?.face(#111) TerminalResistance=50ohm
  P2_T2: Terminal port=P2 Faces=?.face(#163) TerminalResistance=50ohm
  P1: Wave Port Faces=?.face(#240) WavePortType=Terminal NumModes=1
  P2: Wave Port Faces=?.face(#267) WavePortType=Terminal NumModes=1
  1: Lumped Port Objects=port1_sheet LumpedPortType=Terminal Impedance=50ohm
  2: Lumped Port Objects=port2_sheet LumpedPortType=Terminal Impedance=50ohm
  reference conductors: outer
source amplitudes:
  P1:1: 1 0deg
  P1:2, P2:1, P2:2: 0V 0deg

design Hfss_Transient (HFSS, HFSS Terminal Network, model units mm)
options: Allow_Material_Override Save_Adaptive_support_files
geometry:
  outer, left, right, port1_sheet, port2_sheet [pec] = imported_body()
  group body = outer, left, right, port1_sheet, port2_sheet
boundaries and excitations:
  P1_T1: Terminal port=P1 Faces=?.face(#120) TerminalResistance=50ohm
  P1_T2: Terminal port=P1 Faces=?.face(#172) TerminalResistance=50ohm
  P2_T1: Terminal port=P2 Faces=?.face(#111) TerminalResistance=50ohm
  P2_T2: Terminal port=P2 Faces=?.face(#163) TerminalResistance=50ohm
  P1: Wave Port Faces=?.face(#240) WavePortType=Terminal NumModes=1
  P2: Wave Port Faces=?.face(#267) WavePortType=Terminal NumModes=1
  1: Lumped Port Objects=port1_sheet LumpedPortType=Terminal Impedance=50ohm
  2: Lumped Port Objects=port2_sheet LumpedPortType=Terminal Impedance=50ohm
  reference conductors: outer
source amplitudes:
  P1:1: 1 0deg
  P1:2, P2:1, P2:2: 0V 0deg

design EMDesign1 (HFSS 3D Layout)
ports:
  Port1, Port2: Properties{Impedance=50ohm Magnitude=1V Phase=0deg Renormalize_Impedence="50ohm + 0i ohm" Renormalize Deembed_Distance=0mm Deembed Type="Single Strip Gap Source" HFSS_Type=Gap Orientation=Vertical Layer_Alignment=Upper Horizontal_Extent_Factor=5 Vertical_Extent_Factor=3 PEC_Launch_Width=0.5mm} Type=EdgePort
  Port3, Port4: Properties{Impedance=50ohm Magnitude=1V Phase=0deg Renormalize_Impedence="50ohm + 0i ohm" Renormalize Deembed_Distance=0mm Deembed Type="Single Strip Gap Source" HFSS_Type=Gap Orientation=Vertical Layer_Alignment=Upper Horizontal_Extent_Factor=5 Vertical_Extent_Factor=3 PEC_Launch_Width=0.4mm} Type=EdgePort
  Port5, Port6: Properties{Impedance=50ohm Magnitude=1V Phase=0deg Renormalize_Impedence="50ohm + 0i ohm" Renormalize Deembed_Distance=0mm Deembed Type="Single Strip Gap Source" HFSS_Type=Gap Orientation=Vertical Layer_Alignment=Upper Horizontal_Extent_Factor=5 Vertical_Extent_Factor=3 PEC_Launch_Width=0.6mm} Type=EdgePort

design Circuit1 (Circuit)
options: SParamCircuitDef IntegrationMethod=FFT
components:
  C2 = CAP_()
  C3 = CAP_()
  C4 = CAP_()
  port Port1 rz=50ohm iz=0ohm EnableNoise=false noisetemp=16.85cel
  port Port2 rz=50ohm iz=0ohm EnableNoise=false noisetemp=16.85cel
  port Port3 rz=50ohm iz=0ohm EnableNoise=false noisetemp=16.85cel
  port Port4 rz=50ohm iz=0ohm EnableNoise=false noisetemp=16.85cel
  port Port5 rz=50ohm iz=0ohm EnableNoise=false noisetemp=16.85cel
  port Port6 rz=50ohm iz=0ohm EnableNoise=false noisetemp=16.85cel
nets:
  Port1: C2.0
  Port2: C2.1
  Port3: C3.0
  Port4: C3.1
  Port5: C4.0
  Port6: C4.1
