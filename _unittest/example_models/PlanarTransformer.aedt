# Ansys Electronics Desktop project, version 2021.2
project datasets:
  $Mu_3F3: (0, 2000) (98459.682, 2027.2) (197983.6, 2051) (398107.17, 2100) (494745.69, 2124) (596047.54, 2174) (696140.06, 2251.3) (788186.9, 2304.4) (892404.59, 2386.3) (994839.02, 2500.2) (1126381.2, 2589.1) (1255672.6, 2619.4) (1378243.2, 2619.4) (1536444.4, 2559.1) (1712804.8, 2414.3) (1822527.8, 2251.3) (1969618.1, 2075) (2161879.4, 1846.9) (2372908, 1550.8) (2604535.8, 1242.9) (2814739.5, 1019.6) (3287410.5, 603.6) (3780315.9, 300) (4214238.4, 188.3) (4625605, 122.3) (4846109.9, 100.3) (5156553.8, 88.3) (5402369.3, 77.7) (5659903, 70) (6116695.4, 60.1) (6713767.4, 49.3) (7963859.6, 39.5) (9016877.7, 34.3) (10209131, 31.3) (11559029, 28.8)
materials:
  vacuum: permittivity=1
  Material_3F3: permeability=pwl($Mu_3F3,Freq) conductivity=0.5 core_loss_type="Power Ferrite" core_loss_cm=0.195 core_loss_x=1.561 core_loss_y=2.15
  copper: permeability=0.999991 conductivity=58000000
  polyamide: permittivity=4.3 dielectric_loss_tangent=0.004
  copper_temp: thermal_modifier{Property=conductivity free_form_value=1/(1+0.0039*(Temp-22))} permeability=0.999991 conductivity=58000000
  air: permittivity=1.0006 permeability=1.0000004
  Al-Extruded
surface materials:
  Steel-oxidised-surface

design Maxwell3D (Maxwell 3D, EddyCurrent, model units mm)
notes: Notes: Due to higher frequency operations of planar transformers, the skin depth and proximity effects play a major role on the proper electromagnetic design process. Therefore, current 3D Maxwell design is using eddy-current solver to predict the electromagnetic harmonic characteristics of a planar transformer as Current vs Phase angle, Leakage Inductance and Electromagnetic Loss
options: Notes="Notes: Due to higher frequency operations of planar transformers, the skin depth and proximity effects play a major role on the proper electromagnetic design process. Therefore, current 3D Maxwell design is using eddy-current solver to predict the electromagnetic harmonic characteristics of a planar transformer as Current vs Phase angle, Leakage Inductance and Electromagnetic Loss"
variables:
  Vp = 50V
  Rload = 0.4ohm
geometry:
  PQ_Core_Bottom [Material_3F3] = box(corner=(-10.65mm, -7mm, -3.5mm), size=(4.65mm, 14mm, 3.5mm))
  Polyline1 = polyline(z=-3.5mm, xy in mm: (-6, -5.6) (-6, 5.6) (-2, 3.9191836) (-2, -3.9191836) (-6, -5.6), closed, covered)
  Polyline1.sweep_along_vector((0mm, 0mm, 3.5mm))
  PQ_Core_Bottom.unite(Polyline1)
  XCyl1 = cylinder(axis=Z, base_centre=(0mm, 0mm, -1.5mm), radius=9mm, height=1.5mm)
  PQ_Core_Bottom.subtract(XCyl1)
  PQ_Core_Bottom_1 = PQ_Core_Bottom.duplicate_mirror(point=(0mm, 0mm, 0mm), normal=(1mm, 0mm, 0mm))
  XCyl2 = cylinder(axis=Z, base_centre=(0mm, 0mm, -3.5mm), radius=4.4mm, height=3.5mm)
  PQ_Core_Bottom.unite(PQ_Core_Bottom_1, XCyl2)
  PQ_Core_Top [Material_3F3] = PQ_Core_Bottom.duplicate_mirror(point=(0mm, 0mm, 0mm), normal=(0mm, 0mm, 1mm))
  Board_1 [polyamide] = cylinder(axis=Z, base_centre=(0mm, 0mm, -1.5mm), radius=9mm, height=0.2mm)
  BoardSlot_1 = cylinder(axis=Z, base_centre=(0mm, 0mm, -1.5mm), radius=4.4mm, height=3mm)
  Board_1.subtract(BoardSlot_1)
  Tool1_1 = circle(normal=Z, centre=(0mm, 0mm, -0.15mm), radius=6.45mm, uncovered)
  Layer1_1 [copper_temp] = rectangle(corner=(4.45mm, 0mm, -0.3mm), z_size=0.3mm, x_size=4mm)
  Layer1_1.sweep_along_path(Tool1_1)
  Layer1_1.move(0mm, 0mm, -1mm)
  Board_2 [polyamide] = cylinder(axis=Z, base_centre=(0mm, 0mm, -1mm), radius=9mm, height=0.2mm)
  BoardSlot_2 = cylinder(axis=Z, base_centre=(0mm, 0mm, -1mm), radius=4.4mm, height=3mm)
  Board_2.subtract(BoardSlot_2)
  Tool2_1 = circle(normal=Z, centre=(0mm, 0mm, -0.15mm), radius=6.45mm, uncovered)
  Layer2_1 [copper_temp] = rectangle(corner=(4.45mm, 0mm, -0.3mm), z_size=0.3mm, x_size=4mm)
  Layer2_1.sweep_along_path(Tool2_1)
  Layer2_1.move(0mm, 0mm, -0.5mm)
  Board_3 [polyamide] = cylinder(axis=Z, base_centre=(0mm, 0mm, -0.5mm), radius=9mm, height=0.2mm)
  BoardSlot_3 = cylinder(axis=Z, base_centre=(0mm, 0mm, -0.5mm), radius=4.4mm, height=3mm)
  Board_3.subtract(BoardSlot_3)
  Tool3_1 = circle(normal=Z, centre=(0mm, 0mm, -0.15mm), radius=6.45mm, uncovered)
  Layer3_1 [copper_temp] = rectangle(corner=(4.45mm, 0mm, -0.3mm), z_size=0.3mm, x_size=4mm)
  Layer3_1.sweep_along_path(Tool3_1)
  Layer3_1.move(0mm, 0mm, 0mm)
  Board_4 [polyamide] = cylinder(axis=Z, base_centre=(0mm, 0mm, 0mm), radius=9mm, height=0.2mm)
  BoardSlot_4 = cylinder(axis=Z, base_centre=(0mm, 0mm, 0mm), radius=4.4mm, height=3mm)
  Board_4.subtract(BoardSlot_4)
  Tool4_1 = circle(normal=Z, centre=(0mm, 0mm, -0.15mm), radius=6.45mm, uncovered)
  Layer4_1 [copper_temp] = rectangle(corner=(4.45mm, 0mm, -0.3mm), z_size=0.3mm, x_size=4mm)
  Layer4_1.sweep_along_path(Tool4_1)
  Layer4_1.move(0mm, 0mm, 0.5mm)
  Board_5 [polyamide] = cylinder(axis=Z, base_centre=(0mm, 0mm, 0.5mm), radius=9mm, height=0.2mm)
  BoardSlot_5 = cylinder(axis=Z, base_centre=(0mm, 0mm, 0.5mm), radius=4.4mm, height=3mm)
  Board_5.subtract(BoardSlot_5)
  Tool5_1 = circle(normal=Z, centre=(0mm, 0mm, -0.15mm), radius=6.45mm, uncovered)
  Layer5_1 [copper_temp] = rectangle(corner=(4.45mm, 0mm, -0.3mm), z_size=0.3mm, x_size=4mm)
  Layer5_1.sweep_along_path(Tool5_1)
  Layer5_1.move(0mm, 0mm, 1mm)
  Board_6 [polyamide] = cylinder(axis=Z, base_centre=(0mm, 0mm, 1mm), radius=9mm, height=0.2mm)
  BoardSlot_6 = cylinder(axis=Z, base_centre=(0mm, 0mm, 1mm), radius=4.4mm, height=3mm)
  Board_6.subtract(BoardSlot_6)
  Tool6_1 = circle(normal=Z, centre=(0mm, 0mm, -0.15mm), radius=6.45mm, uncovered)
  Layer6_1 [copper_temp] = rectangle(corner=(4.45mm, 0mm, -0.3mm), z_size=0.3mm, x_size=4mm)
  Layer6_1.sweep_along_path(Tool6_1)
  Layer6_1.move(0mm, 0mm, 1.5mm)
  Layer1_1_Section1 [Copper] = Layer1_1.section(plane=ZX)
  Layer2_1_Section1 [Copper] = Layer2_1.section(plane=ZX)
  Layer3_1_Section1 [Copper] = Layer3_1.section(plane=ZX)
  Layer4_1_Section1 [Copper] = Layer4_1.section(plane=ZX)
  Layer5_1_Section1 [Copper] = Layer5_1.section(plane=ZX)
  Layer6_1_Section1 [Copper] = Layer6_1.section(plane=ZX)
  Layer1_1_Section1.separate_bodies()
  Layer2_1_Section1.separate_bodies()
  Layer3_1_Section1.separate_bodies()
  Layer4_1_Section1.separate_bodies()
  Layer5_1_Section1.separate_bodies()
  Layer6_1_Section1.separate_bodies()
  Region [vacuum] = region(percentage_offset=50 on all sides)
boundaries and excitations:
  CoilTerminal_1: Coil Terminal Objects=Layer1_1_Section1 Conductor_number=1 Winding=pri Point_out_of_terminal=false
  CoilTerminal_2: Coil Terminal Objects=Layer2_1_Section1 Conductor_number=1 Winding=pri Point_out_of_terminal=false
  CoilTerminal_3: Coil Terminal Objects=Layer3_1_Section1 Conductor_number=1 Winding=sec Point_out_of_terminal=false
  CoilTerminal_4: Coil Terminal Objects=Layer4_1_Section1 Conductor_number=1 Winding=sec Point_out_of_terminal=false
  CoilTerminal_5: Coil Terminal Objects=Layer5_1_Section1 Conductor_number=1 Winding=pri Point_out_of_terminal=false
  CoilTerminal_6: Coil Terminal Objects=Layer6_1_Section1 Conductor_number=1 Winding=pri Point_out_of_terminal=false
  pri: Winding Group Type=Voltage IsSolid=true Current=0mA Resistance=0ohm Inductance=0nH Voltage=Vp ParallelBranchesNum=1 Phase=0deg
  sec: Winding Group Type=Voltage IsSolid=true Current=0mA Resistance=Rload Inductance=0nH Voltage=0mV ParallelBranchesNum=1 Phase=0deg
  eddy effects on: Layer1_1, Layer2_1, Layer3_1, Layer4_1, Layer5_1, Layer6_1
  core loss on: PQ_Core_Bottom, PQ_Core_Top, Board_1
mesh:
  Length_Coil: LengthBased Objects=[Layer1_1, Layer2_1, Layer3_1, Layer4_1, Layer5_1, Layer6_1] MaxLength=1.065mm
  Length_Core: LengthBased Objects=[PQ_Core_Bottom, PQ_Core_Top] MaxLength=1.065mm
  initial mesh: GlobalCurvilinear{Apply}
temperatures:
  PQ_Core_Bottom, PQ_Core_Top, Board_1..Board_6, Layer1_1_Section1, Layer2_1_Section1, Layer3_1_Section1, Layer4_1_Section1, Layer5_1_Section1, Layer6_1_Section1, Region: 22cel
  Layer1_1, Layer2_1, Layer3_1, Layer4_1, Layer5_1, Layer6_1: 20cel
setups:
  Setup1: EddyCurrent MaximumPasses=5 MinimumPasses=2 MinimumConvergedPasses=1 PercentRefinement=30 PercentError=1 NonLinearResidual=0.0001 Frequency=100000Hz
output variables:
  Lleakage12_from_L11 = L(pri,pri)-2*L(pri,sec)-2*L(sec,pri)+4*L(sec,sec)
  Lleakage12_from_CC = L(pri,pri)*(1-CplCoef(sec,pri)*CplCoef(sec,pri))
field calculator expressions:
  cond = Vector_Constant(1, 0, 0) | MaterialOp(Conductivity (cond)) | Mag
  Ipri = <Jx,Jy,Jz> | ScalarY | Scalar_Function(FuncValue='Phase') | AtPhase | EnterSurface(Layer1_1_Section1) | SurfaceValue | Integrate
  Isec = <Jx,Jy,Jz> | ScalarY | Scalar_Function(FuncValue='Phase') | AtPhase | EnterSurface(Layer3_1_Section1) | SurfaceValue | Integrate
field plots:
  cond1: Conductivity over Layer1_1, Layer2_1, Layer3_1, Layer4_1, Layer5_1, Layer6_1 on Setup1 : LastAdaptive at Freq=100000Hz Phase=0deg
  Mag_B1: B over PQ_Core_Top, PQ_Core_Bottom on Setup1 : LastAdaptive at Freq=100000Hz Phase=0deg
  Mag_J1: J over Layer1_1, Layer2_1, Layer3_1, Layer4_1, Layer5_1, Layer6_1 on Setup1 : LastAdaptive at Freq=100000Hz Phase=0deg
  Ohmic_Loss1: Ohmic-Loss over Layer1_1, Layer2_1, Layer3_1, Layer4_1, Layer5_1, Layer6_1 on Setup1 : LastAdaptive at Freq=100000Hz Phase=0deg
  Core_Loss1: Core-Loss over PQ_Core_Top, PQ_Core_Bottom on Setup1 : LastAdaptive at Freq=100000Hz Phase=0deg
  Temperature1: Temperature over Layer1_1, Layer2_1, Layer3_1, Layer4_1, Layer5_1, Layer6_1 on Setup1 : LastAdaptive at Freq=100000Hz Phase=0deg
reports:
  Current vs Phase angle: Ipri, Isec vs Phase on Setup1 : LastAdaptive [Freq=all]
  Loss: CoreLoss, SolidLoss vs Freq on Setup1 : LastAdaptive
