# Ansys Electronics Desktop project, version 2019.3
materials:
  vacuum: permittivity=1
  copper: permeability=0.999991 conductivity=58000000

design simple_primitives (HFSS, DrivenModal, model units mm)
geometry:
  Mybox [copper] = box(corner=(0mm, 0mm, 0mm), size=(10mm, 10mm, 5mm))
  MyCyl [vacuum] = cylinder(axis=Y, base_centre=(20mm, 20mm, 0mm), radius=5mm, height=50mm, segments=8)
  MyRectangle [copper] = rectangle(corner=(5mm, 3mm, 8mm), x_size=4mm, y_size=5mm)
  Poly1 = polyline(xyz in mm: (0, 0, 0) (2, 5, 3) (5, 0, 0) (5, 5, 0) (0, 0, 0))
  Poly1_Covered [copper] = polyline(xyz in mm: (0, 0, 0) (2, 5, 3) (5, 0, 0) (5, 5, 0) (0, 0, 0), closed, covered)
  MyCone [vacuum] = cone(axis=Z, base_centre=(5mm, 3mm, 8mm), bottom_radius=20mm, top_radius=10mm, height=5mm)
