# Ansys Electronics Desktop project, version 2022.2
materials:
  AIR: permittivity=1 permeability=1
  BOTTOM_FILL: permittivity=4.5 permeability=1
  COPPER: conductivity=59590000
  FR-4: permittivity=3.86 permeability=1 dielectric_loss_tangent=0.024
  FR-4_1: permittivity=4.34 permeability=1 dielectric_loss_tangent=0.018
  FR-4_2: permittivity=4.5 permeability=1 dielectric_loss_tangent=0.035
  GND_FILL: permittivity=4.5 permeability=1 dielectric_loss_tangent=0.035
  LYR_1_FILL: permittivity=4.5 permeability=1 dielectric_loss_tangent=0.035
  LYR_2_FILL: permittivity=4.5 permeability=1 dielectric_loss_tangent=0.035
  PWR_FILL: permittivity=4.5 permeability=1 dielectric_loss_tangent=0.035
  TOP_FILL: permittivity=4.5 permeability=1
  FR4_epoxy: permittivity=4.4 dielectric_loss_tangent=0.02

design Galileo_G87173_204 (HFSS 3D Layout)
nets:
  BST_V3P3_S5: port U3A1-BST_V3P3_S5
  V3P3_RTC: port U2A5-V3P3_RTC
  V3P3_S5: port U2A3-V3P3_S5, port EU1-V3P3_S5, port U2A5-V3P3_S5, port U2L1-V3P3_S5, port J4A1-V3P3_S5, port J2A1-V3P3_S5, port U2M1-V3P3_S5
setups:
  Siwave_DC_WP9QNY: SolveSetupType=SIwaveDCIR
