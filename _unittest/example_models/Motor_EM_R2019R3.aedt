# Ansys Electronics Desktop project, version 2022.1
materials:
  vacuum: permittivity=1
  M19_26G: permeability{HUnit=A_per_meter BUnit=tesla curve (0, 0) (22.28, 0.05) (25.46, 0.1) (31.83, 0.15) (47.74, 0.36) (63.66, 0.54) (79.57, 0.65) (159.15, 0.99) (318.3, 1.2) (477.46, 1.28) (636.61, 1.33) (795.77, 1.36) (1591.5, 1.44) (3183, 1.52) (4774.6, 1.58) (6366.1, 1.63) (7957.7, 1.67) (15915, 1.8) (31830, 1.9) (111407, 2) (190984, 2.1) (350138, 2.3) (509292, 2.5)} conductivity=1960000 core_loss_type="Electrical Steel" core_loss_kh=164.2 core_loss_kc=0.712 core_loss_ke=0.82 mass_density=7650
  NdFe35: permittivity=1 permeability=1.0997785 conductivity=625000 magnetic_coercivity{Magnitude=-890000A_per_meter DirComp1=1 DirComp2=0 DirComp3=0} lande_g_factor=2
  steel_stainless: conductivity=1100000
  copper: permeability=0.999991 conductivity=58000000

design Basis_Model_For_Test (Maxwell 2D, Transient, XY geometry, model units mm)
options: ModelDepth=83.8mm
variables:
  speed_mech = 3000rpm
  Ipeak = 250A
  pole_pairs = 4
  freq_elec = speed_mech/1per_second*pole_pairs
  gamma = 60deg
  R_measure = 80.775mm
  N_pts = 72
  AngleStep = 360deg/pole_pairs/(6*N_pts)
  Tooth_Arc_length = R_measure*2*pi/8/6
  Tooth_segment = Tooth_Arc_length/N_pts
  N_segments = max(min_N_segment,8*6*N_pts/2)
  min_N_segment = 360deg/AngleStep
  Tstep = 1/freq_elec/N_pts/6
  Init_Pos = 0deg
  R_stator = 80.95mm
  R_rotor = 80mm
  test = 3
geometry:
  Stator_Yoke, Stator_Teeth30, Stator_Teeth32, Stator_Teeth34, Stator_Teeth36, Stator_Teeth38, Stator_Teeth40, Stator_Teeth42, Magnet1, Shaft, Magnet2, Rotor = imported_body(D:\PreSales\Customer\Romax\Recording\Multiphysics_Motor_Geometry.sat)
  Magnet1_Section1 [NdFe35, oriented by ObjectCS1] = Magnet1.section(plane=XY)
  Magnet1.delete()
  Magnet2_Section1 [NdFe35, oriented by ObjectCS2] = Magnet2.section(plane=XY)
  Magnet2.delete()
  Rotor_Section1 [M19_26G] = Rotor.section(plane=XY)
  Rotor.delete()
  Shaft_Section1 [steel_stainless] = Shaft.section(plane=XY)
  Shaft.delete()
  Stator_Teeth30_Section1 [M19_26G] = Stator_Teeth30.section(plane=XY)
  Stator_Teeth30.delete()
  Stator_Teeth32_Section1 [M19_26G] = Stator_Teeth32.section(plane=XY)
  Stator_Teeth32.delete()
  Stator_Teeth34_Section1 [M19_26G] = Stator_Teeth34.section(plane=XY)
  Stator_Teeth34.delete()
  Stator_Teeth36_Section1 [M19_26G] = Stator_Teeth36.section(plane=XY)
  Stator_Teeth36.delete()
  Stator_Teeth38_Section1 [M19_26G] = Stator_Teeth38.section(plane=XY)
  Stator_Teeth38.delete()
  Stator_Teeth40_Section1 [M19_26G] = Stator_Teeth40.section(plane=XY)
  Stator_Teeth40.delete()
  Stator_Teeth42_Section1 [M19_26G] = Stator_Teeth42.section(plane=XY)
  Stator_Teeth42.delete()
  Stator_Yoke_Section1 [M19_26G] = Stator_Yoke.section(plane=XY)
  Stator_Yoke.delete()
  [Stator_Teeth30_Section1, Stator_Teeth32_Section1, Stator_Teeth34_Section1, Stator_Teeth36_Section1, Stator_Teeth38_Section1, Stator_Teeth40_Section1, Stator_Teeth42_Section1, Stator_Yoke_Section1].rotate(axis=Z, angle=-15deg)
  [Magnet1_Section1, Magnet2_Section1, Rotor_Section1, Shaft_Section1, Stator_Teeth30_Section1, Stator_Teeth32_Section1, Stator_Teeth34_Section1, Stator_Teeth36_Section1, Stator_Teeth38_Section1, Stator_Teeth40_Section1, Stator_Teeth42_Section1, Stator_Yoke_Section1].split(plane=ZX, keep=PositiveOnly)
  coordinate_system RelativeCS1 = origin=(0mm, 0mm, 0mm) x=(40mm, -40mm, 0mm) y=(40mm, 40mm, 0mm)
  [Magnet1_Section1, Magnet2_Section1, Rotor_Section1, Shaft_Section1, Stator_Teeth30_Section1, Stator_Teeth32_Section1, Stator_Teeth34_Section1, Stator_Teeth36_Section1, Stator_Teeth38_Section1, Stator_Teeth40_Section1, Stator_Teeth42_Section1, Stator_Yoke_Section1].split(plane=YZ, keep=PositiveOnly) in RelativeCS1
  Band [vacuum] = circle(normal=Z, centre=(0mm, 0mm, 0mm), radius=80.6mm, segments=N_segments)
  Region [vacuum] = circle(normal=Z, centre=(0mm, 0mm, 0mm), radius=140mm)
  [Band, Region].split(plane=ZX, keep=PositiveOnly)
  [Region, Band].split(plane=YZ, keep=PositiveOnly) in RelativeCS1
  coordinate_system ObjectCS1 = object of Magnet1_Section1: Origin=(59.422961, 19.208341, 0) xAxisPos=(63.796371, 23.98994, 0) yAxis{xDirection=-0.73790107 yDirection=0.67490889 zDirection=0}
  coordinate_system ObjectCS2 = object of Magnet2_Section1: Origin=(55.600727, 28.436031, 0) xAxisPos=(62.074296, 28.147398, 0) yAxis{xDirection=0.0445422 yDirection=0.9990075 zDirection=0} in ObjectCS1
  Coil [copper] = rectangle(corner=(88mm, -1.5mm, 0mm), x_size=20mm, y_size=3mm)
  Coil.rotate(axis=Z, angle=3.75deg)
  Coil_1..Coil_5 [copper] = Coil.duplicate_around_axis(axis=Z, angle=7.5deg, total=6)
  coordinate_system RelativeCS2 = origin=(0mm, 0mm, 0mm) x=(40mm, -40mm, 0mm) y=(40mm, 40mm, 0mm)
  coordinate_system RelativeCS3 = origin=(0mm, 0mm, 0mm) x=(40mm, -40mm, 0mm) y=(40mm, 40mm, 0mm)
  tooth_1 = polyline(z=0mm, xy: (R_measure, 0) (74.626369mm, 30.911254mm) (57.11655mm, 57.11655mm), AngularArc from point 0 over 3 centre=(0mm, 0mm, 0mm) angle=45deg plane=XY)
  coordinate_system RelativeCS4 = origin=(0mm, 0mm, 0mm) x=(40mm, -40mm, 0mm) y=(40mm, 40mm, 0mm)
  Airgap [vacuum] = circle(normal=Z, centre=(0mm, 0mm, 0mm), radius=80.95mm)
  Band1 = circle(normal=Z, centre=(0mm, 0mm, 0mm), radius=80.6mm, segments=N_segments)
  Band1.split(plane=ZX, keep=PositiveOnly)
  coordinate_system RelativeCS5 = origin=(0mm, 0mm, 0mm) x=(40mm, -40mm, 0mm) y=(40mm, 40mm, 0mm)
  Band1.split(plane=YZ, keep=PositiveOnly) in RelativeCS5
  Airgap.split(plane=ZX, keep=PositiveOnly)
  Airgap.split(plane=YZ, keep=PositiveOnly) in RelativeCS1
  Airgap.subtract(Band1)
  list Objectlist1 = tooth_1
motion:
  MotionSetup1: Band Move_Type=Rotate Coordinate_System=Global Axis=Z Is_Positive=true InitPos=Init_Pos Angular_Velocity=speed_mech Objects=Band
  Moving1: Moving Objects=[Magnet1_Section1, Magnet2_Section1, Rotor_Section1, Shaft_Section1]
boundaries and excitations:
  Master1: Independent Edges=Region.edge(at (0, 0, 0))
  Slave1: Dependent Edges=Region.edge(at (49.4975, 49.4975, 0)) ReverseU Independent=Master1 SameAsMaster=false
  VectorPotential1: Vector Potential Edges=Region.edge(1 of 1) Value=0
  Coil: Coil Objects=Coil Conductor_number=8 Winding=PhaseA PolarityType=Positive
  Coil_1: Coil Objects=Coil_1 Conductor_number=8 Winding=PhaseA PolarityType=Positive
  Coil_2: Coil Objects=Coil_2 Conductor_number=8 Winding=PhaseC PolarityType=Negative
  Coil_3: Coil Objects=Coil_3 Conductor_number=8 Winding=PhaseC PolarityType=Negative
  Coil_4: Coil Objects=Coil_4 Conductor_number=8 Winding=PhaseB PolarityType=Positive
  Coil_5: Coil Objects=Coil_5 Conductor_number=8 Winding=PhaseB PolarityType=Positive
  Current_1: Current Objects=Magnet1_Section1 Current=0mA IsSolid=true IsPositive=true
  Current_2: Current Objects=Magnet2_Section1 Current=0mA IsSolid=true IsPositive=true
  PhaseA: Winding Group Type=Voltage IsSolid=false Current=Ipeak*cos(2*pi*freq_elec*time-gamma) Resistance=1ohm Inductance=0nH Voltage=0mV ParallelBranchesNum=1
  PhaseB: Winding Group Type=Voltage IsSolid=false Current=Ipeak*cos(2*pi*freq_elec*time-gamma-120deg) Resistance=1ohm Inductance=0nH Voltage=0mV ParallelBranchesNum=1
  PhaseC: Winding Group Type=Voltage IsSolid=false Current=Ipeak*cos(2*pi*freq_elec*time-gamma-240deg) Resistance=1ohm Inductance=0nH Voltage=0mV ParallelBranchesNum=1
  core loss on: Magnet1_Section1, Magnet2_Section1, Rotor_Section1, Shaft_Section1, Stator_Teeth30_Section1, Stator_Teeth32_Section1, Stator_Teeth34_Section1, Stator_Teeth36_Section1, Stator_Teeth38_Section1, Stator_Teeth40_Section1, Stator_Teeth42_Section1, Stator_Yoke_Section1, Band, Region, Coil, Coil_1..Coil_5
parameters:
  Torque_Stator: Torque Coordinate_System=Global Is_Positive=true Objects=[Stator_Teeth30_Section1, Stator_Teeth32_Section1, Stator_Teeth34_Section1, Stator_Teeth36_Section1, Stator_Teeth38_Section1, Stator_Teeth40_Section1, Stator_Teeth42_Section1, Stator_Yoke_Section1]
  Torque_Coils: Torque Coordinate_System=Global Is_Positive=true Objects=[Coil, Coil_1..Coil_5]
mesh:
  Length_Rotor: LengthBased RefineInside Objects=Rotor_Section1 MaxLength=3mm
  Length_Stator: LengthBased RefineInside Objects=[Stator_Teeth30_Section1, Stator_Teeth32_Section1, Stator_Teeth34_Section1, Stator_Teeth36_Section1, Stator_Teeth38_Section1, Stator_Teeth40_Section1, Stator_Teeth42_Section1] MaxLength=2mm
  Length_Yoke: LengthBased RefineInside Objects=Stator_Yoke_Section1 MaxLength=3mm
  Length_coils: LengthBased RefineInside Objects=[Coil, Coil_1..Coil_5] MaxLength=5mm
  Length_Magnets: LengthBased RefineInside Objects=[Magnet1_Section1, Magnet2_Section1] MaxLength=2.5mm
  Length_Rotor_edge: LengthBased Edges=Rotor_Section1.edge(at (56.71, 56.71, 0)) MaxLength=2*pi*R_rotor/8/6/N_pts*2
  Length_Region: LengthBased RefineInside Objects=Region MaxLength=20mm
  Length_Tooth_Surface: LengthBased Edges=Stator_Teeth30_Section1.edge(8 of 10) Stator_Teeth32_Section1.edge(6 of 10) Stator_Teeth34_Section1.edge(3 of 10) Stator_Teeth36_Section1.edge(6 of 10) Stator_Teeth40_Section1.edge(6 of 10) Stator_Teeth38_Section1.edge(7 of 10) Stator_Teeth42_Section1.edge(9 of 10) MaxLength=2*pi*R_stator/8/6/N_pts*2
  CylindricalGap1: CylindricalGap Objects=Band
  initial mesh: MeshMethod=AnsoftTAU
setups:
  Setup1: Transient NonlinearSolverResidual=1e-07 StopTime=1/freq_elec*0+2*Tstep TimeStep=Tstep CallCtrlProgAfterLastStep InitialTimeStep=0.002s MinTimeStep=0.001s MaxTimeStep=0.003s TimeStepErrTolerance=0.0001
optimetrics:
  ParametricSetup1: Parametric InterpolationPoints=0 Sim._Setups=[Setup1]
    sweep speed_mech: LIN 1500rpm 4500rpm 1500rpm
output variables:
  F_rad_1 = ExprCache(F_tooth_1_x1)*cos(1*7.5deg)+ExprCache(F_tooth_1_y1)*sin(1*7.5deg)
  F_tan_1 = -ExprCache(F_tooth_1_x1)*sin(1*7.5deg)+ExprCache(F_tooth_1_y1)*cos(1*7.5deg)
  F_rad_2 = ExprCache(F_tooth_2_x1)*cos(2*7.5deg)+ExprCache(F_tooth_2_y1)*sin(2*7.5deg)
  F_tan_2 = -ExprCache(F_tooth_2_x1)*sin(2*7.5deg)+ExprCache(F_tooth_2_y1)*cos(2*7.5deg)
  F_tan_3 = -ExprCache(F_tooth_3_x1)*sin(3*7.5deg)+ExprCache(F_tooth_3_y1)*cos(3*7.5deg)
  F_tan_4 = -ExprCache(F_tooth_4_x1)*sin(4*7.5deg)+ExprCache(F_tooth_4_y1)*cos(4*7.5deg)
  F_tan_5 = -ExprCache(F_tooth_5_x1)*sin(5*7.5deg)+ExprCache(F_tooth_5_y1)*cos(5*7.5deg)
  F_rad_3 = ExprCache(F_tooth_3_x1)*cos(3*7.5deg)+ExprCache(F_tooth_3_y1)*sin(3*7.5deg)
  F_rad_4 = ExprCache(F_tooth_4_x1)*cos(4*7.5deg)+ExprCache(F_tooth_4_y1)*sin(4*7.5deg)
  F_rad_5 = ExprCache(F_tooth_5_x1)*cos(5*7.5deg)+ExprCache(F_tooth_5_y1)*sin(5*7.5deg)
  F_rad_0_pos = ExprCache(F_tooth_0_pos_x1)*cos(0*7.5deg)+ExprCache(F_tooth_0_pos_y1)*sin(0*7.5deg)
  F_rad_0_neg = ExprCache(F_tooth_0_neg_x1)*cos(6*7.5deg)+ExprCache(F_tooth_0_neg_y1)*sin(6*7.5deg)
  F_rad_0 = F_rad_0_neg+F_rad_0_pos
  F_tan_0_neg = -ExprCache(F_tooth_0_neg_x1)*sin(6*7.5deg)+ExprCache(F_tooth_0_neg_y1)*cos(6*7.5deg)
  F_tan_0_pos = -ExprCache(F_tooth_0_pos_x1)*sin(0*7.5deg)+ExprCache(F_tooth_0_pos_y1)*cos(0*7.5deg)
  F_tan_0 = F_tan_0_neg+F_tan_0_pos
  F_tan_sum = (F_tan_0+F_tan_1+F_tan_2+F_tan_3+F_tan_4+F_tan_5)*8*0.0838*R_measure
  Airgap_Torque = ExprCache(Int_Trq_Lines1)*0.0838*8
field calculator expressions:
  fdens_x = Fundamental_Quantity(22) | ScalarX | Fundamental_Quantity(21) | ScalarX | * | Fundamental_Quantity(22) | ScalarY | Fundamental_Quantity(21) | ScalarY | * | - | 2 | / | VecX | Fundamental_Quantity(22) | ScalarX | Fundamental_Quantity(21) | ScalarY | * | VecY | + | 2D_Normal | Dot
  fdens_y = Fundamental_Quantity(22) | ScalarY | Fundamental_Quantity(21) | ScalarX | * | VecX | Fundamental_Quantity(22) | ScalarY | Fundamental_Quantity(21) | ScalarY | * | Fundamental_Quantity(22) | ScalarX | Fundamental_Quantity(21) | ScalarX | * | - | 2 | / | VecY | + | 2D_Normal | Dot
  dM = Scalar_Function(FuncValue='X') | fdens_y | * | Scalar_Function(FuncValue='Y') | fdens_x | * | -
  F_tooth_1_x = fdens_x | EnterLine(tooth_1) | LineValue | Integrate
  F_tooth_1_y = fdens_y | EnterLine(tooth_1) | LineValue | Integrate
  Int_Trq_Lines = dM | EnterLine(Objectlist1) | LineValue | Integrate
  Trq_Line1 = dM | EnterLine(tooth_1) | LineValue | Integrate
  Bx = Fundamental_Quantity(22) | ScalarX
  By = Fundamental_Quantity(22) | ScalarY
  Br = Fundamental_Quantity(22) | Vector_Function(FuncValueX='0mm', FuncValueY='0mm', FuncValueZ='0mm') | ToCylindrical | ScalarX
  Bt = Fundamental_Quantity(22) | Vector_Function(FuncValueX='0mm', FuncValueY='0mm', FuncValueZ='0mm') | ToCylindrical | ScalarY
  mu0 = 1.25664e-06
  Fdens_r = Br | Br | * | Bt | Bt | * | - | mu0 | 2 | * | /
  Fdens_t = Br | Bt | * | mu0 | /
  B_radial = Fundamental_Quantity(22) | ScalarX | Scalar_Function(FuncValue='PHI') | UMathFunc | * | Fundamental_Quantity(22) | ScalarY | Scalar_Function(FuncValue='PHI') | UMathFunc | * | +
  B_tangential = Fundamental_Quantity(22) | ScalarX | -1 | * | Scalar_Function(FuncValue='PHI') | UMathFunc | * | Fundamental_Quantity(22) | ScalarY | Scalar_Function(FuncValue='PHI') | UMathFunc | * | +
  f_radial = B_radial | 2 | Pow | B_tangential | 2 | Pow | - | 2.51327e-06 | /
  f_tangential = B_radial | B_tangential | * | 1.25664e-06 | /
field plots:
  Mesh1: MeshPlots over a plane on Setup1 : Transient at Time=-1
reports:
  Torque: Moving1.Torque vs Time on Setup1 : Transient

design Y_Connections (Maxwell 2D, Transient, XY geometry, model units mm)
options: ModelDepth=83.8mm
variables:
  speed_mech = 3000rpm
  Ipeak = 250A
  pole_pairs = 4
  freq_elec = speed_mech/1per_second*pole_pairs
  gamma = 60deg
  R_measure = 80.775mm
  N_pts = 72
  AngleStep = 360deg/pole_pairs/(6*N_pts)
  Tooth_Arc_length = R_measure*2*pi/8/6
  Tooth_segment = Tooth_Arc_length/N_pts
  N_segments = max(min_N_segment,8*6*N_pts/2)
  min_N_segment = 360deg/AngleStep
  Tstep = 1/freq_elec/N_pts/6
  Init_Pos = 0deg
  R_stator = 80.95mm
  R_rotor = 80mm
  test = 3
geometry:
  Stator_Yoke, Stator_Teeth30, Stator_Teeth32, Stator_Teeth34, Stator_Teeth36, Stator_Teeth38, Stator_Teeth40, Stator_Teeth42, Magnet1, Shaft, Magnet2, Rotor = imported_body(D:\PreSales\Customer\Romax\Recording\Multiphysics_Motor_Geometry.sat)
  Magnet1_Section1 [NdFe35, oriented by ObjectCS1] = Magnet1.section(plane=XY)
  Magnet1.delete()
  Magnet2_Section1 [NdFe35, oriented by ObjectCS2] = Magnet2.section(plane=XY)
  Magnet2.delete()
  Rotor_Section1 [M19_26G] = Rotor.section(plane=XY)
  Rotor.delete()
  Shaft_Section1 [steel_stainless] = Shaft.section(plane=XY)
  Shaft.delete()
  Stator_Teeth30_Section1 [M19_26G] = Stator_Teeth30.section(plane=XY)
  Stator_Teeth30.delete()
  Stator_Teeth32_Section1 [M19_26G] = Stator_Teeth32.section(plane=XY)
  Stator_Teeth32.delete()
  Stator_Teeth34_Section1 [M19_26G] = Stator_Teeth34.section(plane=XY)
  Stator_Teeth34.delete()
  Stator_Teeth36_Section1 [M19_26G] = Stator_Teeth36.section(plane=XY)
  Stator_Teeth36.delete()
  Stator_Teeth38_Section1 [M19_26G] = Stator_Teeth38.section(plane=XY)
  Stator_Teeth38.delete()
  Stator_Teeth40_Section1 [M19_26G] = Stator_Teeth40.section(plane=XY)
  Stator_Teeth40.delete()
  Stator_Teeth42_Section1 [M19_26G] = Stator_Teeth42.section(plane=XY)
  Stator_Teeth42.delete()
  Stator_Yoke_Section1 [M19_26G] = Stator_Yoke.section(plane=XY)
  Stator_Yoke.delete()
  [Stator_Teeth30_Section1, Stator_Teeth32_Section1, Stator_Teeth34_Section1, Stator_Teeth36_Section1, Stator_Teeth38_Section1, Stator_Teeth40_Section1, Stator_Teeth42_Section1, Stator_Yoke_Section1].rotate(axis=Z, angle=-15deg)
  [Magnet1_Section1, Magnet2_Section1, Rotor_Section1, Shaft_Section1, Stator_Teeth30_Section1, Stator_Teeth32_Section1, Stator_Teeth34_Section1, Stator_Teeth36_Section1, Stator_Teeth38_Section1, Stator_Teeth40_Section1, Stator_Teeth42_Section1, Stator_Yoke_Section1].split(plane=ZX, keep=PositiveOnly)
  coordinate_system RelativeCS1 = origin=(0mm, 0mm, 0mm) x=(40mm, -40mm, 0mm) y=(40mm, 40mm, 0mm)
  [Magnet1_Section1, Magnet2_Section1, Rotor_Section1, Shaft_Section1, Stator_Teeth30_Section1, Stator_Teeth32_Section1, Stator_Teeth34_Section1, Stator_Teeth36_Section1, Stator_Teeth38_Section1, Stator_Teeth40_Section1, Stator_Teeth42_Section1, Stator_Yoke_Section1].split(plane=YZ, keep=PositiveOnly) in RelativeCS1
  Band [vacuum] = circle(normal=Z, centre=(0mm, 0mm, 0mm), radius=80.6mm, segments=N_segments)
  Region [vacuum] = circle(normal=Z, centre=(0mm, 0mm, 0mm), radius=140mm)
  [Band, Region].split(plane=ZX, keep=PositiveOnly)
  [Region, Band].split(plane=YZ, keep=PositiveOnly) in RelativeCS1
  coordinate_system ObjectCS1 = object of Magnet1_Section1: Origin=(59.422961, 19.208341, 0) xAxisPos=(63.796371, 23.98994, 0) yAxis{xDirection=-0.73790107 yDirection=0.67490889 zDirection=0}
  coordinate_system ObjectCS2 = object of Magnet2_Section1: Origin=(55.600727, 28.436031, 0) xAxisPos=(62.074296, 28.147398, 0) yAxis{xDirection=0.0445422 yDirection=0.9990075 zDirection=0} in ObjectCS1
  Coil [copper] = rectangle(corner=(88mm, -1.5mm, 0mm), x_size=20mm, y_size=3mm)
  Coil.rotate(axis=Z, angle=3.75deg)
  Coil_1..Coil_5 [copper] = Coil.duplicate_around_axis(axis=Z, angle=7.5deg, total=6)
  coordinate_system RelativeCS2 = origin=(0mm, 0mm, 0mm) x=(40mm, -40mm, 0mm) y=(40mm, 40mm, 0mm)
  coordinate_system RelativeCS3 = origin=(0mm, 0mm, 0mm) x=(40mm, -40mm, 0mm) y=(40mm, 40mm, 0mm)
  tooth_1 = polyline(z=0mm, xy: (R_measure, 0) (74.626369mm, 30.911254mm) (57.11655mm, 57.11655mm), AngularArc from point 0 over 3 centre=(0mm, 0mm, 0mm) angle=45deg plane=XY)
  coordinate_system RelativeCS4 = origin=(0mm, 0mm, 0mm) x=(40mm, -40mm, 0mm) y=(40mm, 40mm, 0mm)
  Airgap [vacuum] = circle(normal=Z, centre=(0mm, 0mm, 0mm), radius=80.95mm)
  Band1 = circle(normal=Z, centre=(0mm, 0mm, 0mm), radius=80.6mm, segments=N_segments)
  Band1.split(plane=ZX, keep=PositiveOnly)
  coordinate_system RelativeCS5 = origin=(0mm, 0mm, 0mm) x=(40mm, -40mm, 0mm) y=(40mm, 40mm, 0mm)
  Band1.split(plane=YZ, keep=PositiveOnly) in RelativeCS5
  Airgap.split(plane=ZX, keep=PositiveOnly)
  Airgap.split(plane=YZ, keep=PositiveOnly) in RelativeCS1
  Airgap.subtract(Band1)
  list Objectlist1 = tooth_1
motion:
  MotionSetup1: Band Move_Type=Rotate Coordinate_System=Global Axis=Z Is_Positive=true InitPos=Init_Pos Angular_Velocity=speed_mech Objects=Band
  Moving1: Moving Objects=[Magnet1_Section1, Magnet2_Section1, Rotor_Section1, Shaft_Section1]
boundaries and excitations:
  Master1: Independent Edges=Region.edge(at (0, 0, 0))
  Slave1: Dependent Edges=Region.edge(at (49.4975, 49.4975, 0)) ReverseU Independent=Master1 SameAsMaster=false
  VectorPotential1: Vector Potential Edges=Region.edge(1 of 1) Value=0
  Coil: Coil Objects=Coil Conductor_number=8 Winding=PhaseA PolarityType=Positive
  Coil_1: Coil Objects=Coil_1 Conductor_number=8 Winding=PhaseA PolarityType=Positive
  Coil_2: Coil Objects=Coil_2 Conductor_number=8 Winding=PhaseC PolarityType=Negative
  Coil_3: Coil Objects=Coil_3 Conductor_number=8 Winding=PhaseC PolarityType=Negative
  Coil_4: Coil Objects=Coil_4 Conductor_number=8 Winding=PhaseB PolarityType=Positive
  Coil_5: Coil Objects=Coil_5 Conductor_number=8 Winding=PhaseB PolarityType=Positive
  Current_1: Current Objects=Magnet1_Section1 Current=0mA IsSolid=true IsPositive=true
  Current_2: Current Objects=Magnet2_Section1 Current=0mA IsSolid=true IsPositive=true
  PhaseA: Winding Group Type=Voltage IsSolid=false Current=Ipeak*cos(2*pi*freq_elec*time-gamma) Resistance=1ohm Inductance=0nH Voltage=0mV ParallelBranchesNum=1
  PhaseB: Winding Group Type=Voltage IsSolid=false Current=Ipeak*cos(2*pi*freq_elec*time-gamma-120deg) Resistance=1ohm Inductance=0nH Voltage=0mV ParallelBranchesNum=1
  PhaseC: Winding Group Type=Voltage IsSolid=false Current=Ipeak*cos(2*pi*freq_elec*time-gamma-240deg) Resistance=1ohm Inductance=0nH Voltage=0mV ParallelBranchesNum=1
  core loss on: Magnet1_Section1, Magnet2_Section1, Rotor_Section1, Shaft_Section1, Stator_Teeth30_Section1, Stator_Teeth32_Section1, Stator_Teeth34_Section1, Stator_Teeth36_Section1, Stator_Teeth38_Section1, Stator_Teeth40_Section1, Stator_Teeth42_Section1, Stator_Yoke_Section1, Band, Region, Coil, Coil_1..Coil_5
parameters:
  Torque_Stator: Torque Coordinate_System=Global Is_Positive=true Objects=[Stator_Teeth30_Section1, Stator_Teeth32_Section1, Stator_Teeth34_Section1, Stator_Teeth36_Section1, Stator_Teeth38_Section1, Stator_Teeth40_Section1, Stator_Teeth42_Section1, Stator_Yoke_Section1]
  Torque_Coils: Torque Coordinate_System=Global Is_Positive=true Objects=[Coil, Coil_1..Coil_5]
mesh:
  Length_Rotor: LengthBased RefineInside Objects=Rotor_Section1 MaxLength=3mm
  Length_Stator: LengthBased RefineInside Objects=[Stator_Teeth30_Section1, Stator_Teeth32_Section1, Stator_Teeth34_Section1, Stator_Teeth36_Section1, Stator_Teeth38_Section1, Stator_Teeth40_Section1, Stator_Teeth42_Section1] MaxLength=2mm
  Length_Yoke: LengthBased RefineInside Objects=Stator_Yoke_Section1 MaxLength=3mm
  Length_coils: LengthBased RefineInside Objects=[Coil, Coil_1..Coil_5] MaxLength=5mm
  Length_Magnets: LengthBased RefineInside Objects=[Magnet1_Section1, Magnet2_Section1] MaxLength=2.5mm
  Length_Rotor_edge: LengthBased Edges=Rotor_Section1.edge(at (56.71, 56.71, 0)) MaxLength=2*pi*R_rotor/8/6/N_pts*2
  Length_Region: LengthBased RefineInside Objects=Region MaxLength=20mm
  Length_Tooth_Surface: LengthBased Edges=Stator_Teeth30_Section1.edge(8 of 10) Stator_Teeth32_Section1.edge(6 of 10) Stator_Teeth34_Section1.edge(3 of 10) Stator_Teeth36_Section1.edge(6 of 10) Stator_Teeth40_Section1.edge(6 of 10) Stator_Teeth38_Section1.edge(7 of 10) Stator_Teeth42_Section1.edge(9 of 10) MaxLength=2*pi*R_stator/8/6/N_pts*2
  CylindricalGap1: CylindricalGap Objects=Band
  initial mesh: MeshMethod=AnsoftTAU
setups:
  Setup1: Transient NonlinearSolverResidual=1e-07 StopTime=1/freq_elec*0+2*Tstep TimeStep=Tstep CallCtrlProgAfterLastStep InitialTimeStep=0.002s MinTimeStep=0.001s MaxTimeStep=0.003s TimeStepErrTolerance=0.0001
optimetrics:
  ParametricSetup1: Parametric InterpolationPoints=0 Sim._Setups=[Setup1]
    sweep speed_mech: LIN 1500rpm 4500rpm 1500rpm
output variables:
  F_rad_1 = ExprCache(F_tooth_1_x1)*cos(1*7.5deg)+ExprCache(F_tooth_1_y1)*sin(1*7.5deg)
  F_tan_1 = -ExprCache(F_tooth_1_x1)*sin(1*7.5deg)+ExprCache(F_tooth_1_y1)*cos(1*7.5deg)
  F_rad_2 = ExprCache(F_tooth_2_x1)*cos(2*7.5deg)+ExprCache(F_tooth_2_y1)*sin(2*7.5deg)
  F_tan_2 = -ExprCache(F_tooth_2_x1)*sin(2*7.5deg)+ExprCache(F_tooth_2_y1)*cos(2*7.5deg)
  F_tan_3 = -ExprCache(F_tooth_3_x1)*sin(3*7.5deg)+ExprCache(F_tooth_3_y1)*cos(3*7.5deg)
  F_tan_4 = -ExprCache(F_tooth_4_x1)*sin(4*7.5deg)+ExprCache(F_tooth_4_y1)*cos(4*7.5deg)
  F_tan_5 = -ExprCache(F_tooth_5_x1)*sin(5*7.5deg)+ExprCache(F_tooth_5_y1)*cos(5*7.5deg)
  F_rad_3 = ExprCache(F_tooth_3_x1)*cos(3*7.5deg)+ExprCache(F_tooth_3_y1)*sin(3*7.5deg)
  F_rad_4 = ExprCache(F_tooth_4_x1)*cos(4*7.5deg)+ExprCache(F_tooth_4_y1)*sin(4*7.5deg)
  F_rad_5 = ExprCache(F_tooth_5_x1)*cos(5*7.5deg)+ExprCache(F_tooth_5_y1)*sin(5*7.5deg)
  F_rad_0_pos = ExprCache(F_tooth_0_pos_x1)*cos(0*7.5deg)+ExprCache(F_tooth_0_pos_y1)*sin(0*7.5deg)
  F_rad_0_neg = ExprCache(F_tooth_0_neg_x1)*cos(6*7.5deg)+ExprCache(F_tooth_0_neg_y1)*sin(6*7.5deg)
  F_rad_0 = F_rad_0_neg+F_rad_0_pos
  F_tan_0_neg = -ExprCache(F_tooth_0_neg_x1)*sin(6*7.5deg)+ExprCache(F_tooth_0_neg_y1)*cos(6*7.5deg)
  F_tan_0_pos = -ExprCache(F_tooth_0_pos_x1)*sin(0*7.5deg)+ExprCache(F_tooth_0_pos_y1)*cos(0*7.5deg)
  F_tan_0 = F_tan_0_neg+F_tan_0_pos
  F_tan_sum = (F_tan_0+F_tan_1+F_tan_2+F_tan_3+F_tan_4+F_tan_5)*8*0.0838*R_measure
  Airgap_Torque = ExprCache(Int_Trq_Lines1)*0.0838*8
field calculator expressions:
  fdens_x = Fundamental_Quantity(22) | ScalarX | Fundamental_Quantity(21) | ScalarX | * | Fundamental_Quantity(22) | ScalarY | Fundamental_Quantity(21) | ScalarY | * | - | 2 | / | VecX | Fundamental_Quantity(22) | ScalarX | Fundamental_Quantity(21) | ScalarY | * | VecY | + | 2D_Normal | Dot
  fdens_y = Fundamental_Quantity(22) | ScalarY | Fundamental_Quantity(21) | ScalarX | * | VecX | Fundamental_Quantity(22) | ScalarY | Fundamental_Quantity(21) | ScalarY | * | Fundamental_Quantity(22) | ScalarX | Fundamental_Quantity(21) | ScalarX | * | - | 2 | / | VecY | + | 2D_Normal | Dot
  dM = Scalar_Function(FuncValue='X') | fdens_y | * | Scalar_Function(FuncValue='Y') | fdens_x | * | -
  F_tooth_1_x = fdens_x | EnterLine(tooth_1) | LineValue | Integrate
  F_tooth_1_y = fdens_y | EnterLine(tooth_1) | LineValue | Integrate
  Int_Trq_Lines = dM | EnterLine(Objectlist1) | LineValue | Integrate
  Trq_Line1 = dM | EnterLine(tooth_1) | LineValue | Integrate
  Bx = Fundamental_Quantity(22) | ScalarX
  By = Fundamental_Quantity(22) | ScalarY
  Br = Fundamental_Quantity(22) | Vector_Function(FuncValueX='0mm', FuncValueY='0mm', FuncValueZ='0mm') | ToCylindrical | ScalarX
  Bt = Fundamental_Quantity(22) | Vector_Function(FuncValueX='0mm', FuncValueY='0mm', FuncValueZ='0mm') | ToCylindrical | ScalarY
  mu0 = 1.25664e-06
  Fdens_r = Br | Br | * | Bt | Bt | * | - | mu0 | 2 | * | /
  Fdens_t = Br | Bt | * | mu0 | /
  B_radial = Fundamental_Quantity(22) | ScalarX | Scalar_Function(FuncValue='PHI') | UMathFunc | * | Fundamental_Quantity(22) | ScalarY | Scalar_Function(FuncValue='PHI') | UMathFunc | * | +
  B_tangential = Fundamental_Quantity(22) | ScalarX | -1 | * | Scalar_Function(FuncValue='PHI') | UMathFunc | * | Fundamental_Quantity(22) | ScalarY | Scalar_Function(FuncValue='PHI') | UMathFunc | * | +
  f_radial = B_radial | 2 | Pow | B_tangential | 2 | Pow | - | 2.51327e-06 | /
  f_tangential = B_radial | B_tangential | * | 1.25664e-06 | /
field plots:
  Mesh1: MeshPlots over a plane on Setup1 : Transient at Time=-1
reports:
  Torque: Moving1.Torque vs Time on Setup1 : Transient
