# Ansys Electronics Desktop project, version 2021.2
project datasets:
  $Cu_Pure_35: (-273.15, 0.49118388) (-196.15, 0.49118388) (99.85, 1) (726.85, 1)
  $Si_Typical_5: (-273.15, 0.23376623) (-196.15, 0.23376623) (99.85, 1) (726.85, 1)
materials:
  Al-Extruded: thermal_conductivity=205 mass_density=2800 specific_heat=900 thermal_material_type=Solid
  air: permittivity=1.0006 permeability=1.0000004 thermal_conductivity=0.0261 mass_density=1.1614 specific_heat=1005 thermal_expansion_coefficient=0.00333 thermal_material_type=Fluid diffusivity=2.88e-05 molecular_mass=0.028966 viscosity=1.84e-05
  Cu-Pure: thermal_modifier{Property=specific_heat free_form_value=pwl($Cu_Pure_35,Temp)} thermal_conductivity=387.6 mass_density=8933 specific_heat=397 thermal_material_type=Solid
  Glycol-34: thermal_conductivity=0.47 mass_density=1055 specific_heat=3620 thermal_expansion_coefficient=0.00044 thermal_material_type=Fluid molecular_mass=0.062 viscosity=0.00232
  Si-Typical: thermal_modifier{Property=specific_heat free_form_value=pwl($Si_Typical_5,Temp)} thermal_conductivity=180 mass_density=2330 specific_heat=770 thermal_material_type=Solid
surface materials:
  Steel-oxidised-surface: surface_emissivity=0.8

design IcepakDesign1 (Icepak, SteadyState TemperatureAndFlow, model units mm)
options: Default_Fluid_Material=air Default_Solid_Material=Al-Extruded Default_Surface_Material=Steel-oxidised-surface AmbientTemperature=20cel AmbientPressure=0n_per_meter_sq AmbientRadiationTemperature=20cel Gravity_Vector_CS_ID=Global Gravity_Vector_Axis=X Positive=true
geometry:
  Region [air] = region(percentage_offset: +X=50, -X=50, +Y=50, -Y=50, +Z=0, -Z=10)
  coldplate [Al-Extruded] = imported_body(D:\TEMP\ColdplateEx\ColdPlateExample.stp)
  PipeWall [Cu-Pure] = imported_body(D:\TEMP\ColdplateEx\ColdPlateExample.stp)
  Liquid [Glycol-34] = imported_body(D:\TEMP\ColdplateEx\ColdPlateExample.stp)
  Circuit_7, Circuit_8, Circuit_9, Circuit_11, Circuit_10, Circuit_12, Circuit_14, Circuit_13, Circuit_15, Circuit_16, Circuit_18, Circuit_17, Circuit_20, Circuit_19, Circuit_22, Circuit_21, Circuit_5, Circuit_6, Circuit_3, Circuit_4, Circuit_1, Circuit, Circuit_2, Circuit_23..Circuit_26, Circuit_28, Circuit_27, Circuit_29..Circuit_34, Circuit_36, Circuit_35, Circuit_38, Circuit_37, Circuit_39, Circuit_40, Circuit_42, Circuit_41, Circuit_43, Circuit_44, Circuit_46, Circuit_45, Circuit_47, Circuit_48, Circuit_50, Circuit_49, Circuit_51, Circuit_53, Circuit_52, Circuit_55, Circuit_54, Circuit_57, Circuit_56, Circuit_58, Circuit_59, Circuit_61, Circuit_60, Circuit_63, Circuit_62 [Si-Typical] = imported_body(D:\TEMP\ColdplateEx\ColdPlateExample.stp)
  fluid_beams, fluid_beams_1..fluid_beams_6, Inlet, Outlet = imported_body(D:\TEMP\ColdplateEx\ColdPlateExample.stp)
  priority 2: PipeWall
  priority 3: Liquid
  group ColdPlateExample = coldplate, PipeWall, Liquid, Circuit_7, Circuit_8, Circuit_9, Circuit_11, Circuit_10, Circuit_12, Circuit_14, Circuit_13, Circuit_15, Circuit_16, Circuit_18, Circuit_17, Circuit_20, Circuit_19, Circuit_22, Circuit_21, Circuit_5, Circuit_6, Circuit_3, Circuit_4, Circuit_1, Circuit, Circuit_2, Circuit_23..Circuit_26, Circuit_28, Circuit_27, Circuit_29..Circuit_34, Circuit_36, Circuit_35, Circuit_38, Circuit_37, Circuit_39, Circuit_40, Circuit_42, Circuit_41, Circuit_43, Circuit_44, Circuit_46, Circuit_45, Circuit_47, Circuit_48, Circuit_50, Circuit_49, Circuit_51, Circuit_53, Circuit_52, Circuit_55, Circuit_54, Circuit_57, Circuit_56, Circuit_58, Circuit_59, Circuit_61, Circuit_60, Circuit_63, Circuit_62, fluid_beams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
boundaries and excitations:
  Packages: Block Objects=[Circuit_62, Circuit_7, Circuit_8, Circuit_9, Circuit_11, Circuit_10, Circuit_12, Circuit_14, Circuit_13, Circuit_15, Circuit_16, Circuit_18, Circuit_17, Circuit_20, Circuit_19, Circuit_22, Circuit_21, Circuit_5, Circuit_6, Circuit_3, Circuit_4, Circuit_1, Circuit, Circuit_2, Circuit_23..Circuit_26, Circuit_28, Circuit_27, Circuit_29..Circuit_34, Circuit_36, Circuit_35, Circuit_38, Circuit_37, Circuit_39, Circuit_40, Circuit_42, Circuit_41, Circuit_43, Circuit_44, Circuit_46, Circuit_45, Circuit_47, Circuit_48, Circuit_50, Circuit_49, Circuit_51, Circuit_53, Circuit_52, Circuit_55, Circuit_54, Circuit_57, Circuit_56, Circuit_58, Circuit_59, Circuit_61, Circuit_60, Circuit_63] Block_Type=Solid Total_Power=1W
  LiquidInlet: Opening Objects=Inlet Temperature=AmbientTemp External_Rad._Temperature=AmbientRadTemp Inlet_Type=Velocity Static_Pressure=AmbientPressure X_Velocity=0m_per_sec Y_Velocity=0m_per_sec Z_Velocity=-1m_per_sec
  LiquidOutlet: Opening Objects=Outlet Temperature=AmbientTemp External_Rad._Temperature=AmbientRadTemp Inlet_Type=Pressure Total_Pressure=AmbientPressure
mesh:
  MeshRegions:  Global{MeshMethod=MesherHD ComputeGap MeshRegionResolution=5 MinGapX=1mm MinGapY=1mm MinGapZ=1mm Objects=Region FacetLevel=3 ProximitySizeFunction CurvatureSizeFunction OptimizePCBMesh}
  MeshOperations:  Liquid{MaxLevel=0 MinLevel=0 Mesh_Reuse_Enabled Mesh_Reuse_File=D:/__ACTIVE_Projects/AEDT_WT_MeshImport_AUTOMATION/AEDT_WT-MeshScriptDev/Liquid.msh Objects=Liquid Local_Mesh_Parameters_Type="3DPolygon Local Mesh Parameters" Height_count=0 Top_height=0mm Top_ratio=0 Bottom_height=0mm Bottom_ratio=0}
setups:
  Setup1: IcepakSteadyState Flow_Regime=Laminar Include_Temperature=true Include_Flow=true Include_Gravity Solution_Initialization_-_X_Velocity=-0.001m_per_sec Convergence_Criteria_-_Flow=0.001 Convergence_Criteria_-_Energy=1e-07 disabled Radiation_Model=Off Under-relaxation_-_Pressure=0.3 Under-relaxation_-_Momentum=0.7 Under-relaxation_-_Temperature=1 Discretization_Scheme_-_Pressure=Standard Discretization_Scheme_-_Momentum=First Discretization_Scheme_-_Temperature=First Convergence_Criteria_-_Max_Iterations=300
field plots:
  SurfTemperature1: Temperature on Setup1 : SteadyState
  Temperature1, Temperature2: Temperature over a plane on Setup1 : SteadyState
