# Ansys Electronics Desktop project, version 2023.2
materials:
  Al-Extruded: thermal_conductivity=205 mass_density=2800 specific_heat=900 youngs_modulus=69000000000 poissons_ratio=0.33 thermal_expansion_coefficient=2.277e-06 thermal_material_type=Solid
  air: permittivity=1.0006 permeability=1.0000004 thermal_conductivity=0.0261 mass_density=1.1614 specific_heat=1005 thermal_expansion_coefficient=0.00333 thermal_material_type=Fluid diffusivity=2.88e-05 molecular_mass=0.028966 viscosity=1.84e-05 material_refractive_index=1.000293
surface materials:
  Steel-oxidised-surface: surface_emissivity=0.8

design IcepakDesign1 (Icepak, SteadyState TemperatureAndFlow, model units mm)
options: Default_Fluid_Material=air Default_Solid_Material=Al-Extruded Default_Surface_Material=Steel-oxidised-surface AmbientTemperature=20cel AmbientPressure=0n_per_meter_sq AmbientRadiationTemperature=20cel Gravity_Vector_CS_ID=Global Gravity_Vector_Axis=Z Positive=false Altitude=0meter
geometry:
  Region [air] = region(percentage_offset=50 on all sides)
  Box1 [Al-Extruded] = box(corner=(1mm, 1mm, 0mm), size=(6.5mm, 3mm, 2.5mm))
  IcepakDesign1_1 = component(IcepakDesign1, 3D_Component_File_Path=D:/0temp/10_pyaedt_meshing_issue/2d_3d_comp.a3dcomp)
  Box1_1, Rectangle1 [Al-Extruded] = part_of(IcepakDesign1_1)
  Rectangle2 [Al-Extruded] = rectangle(corner=(7.5mm, 1mm, 2.5mm), x_size=3.75mm, y_size=-3mm)
  Box2 [Al-Extruded] = box(corner=(1mm, 0mm, 0mm), size=(2mm, -3mm, 2mm))
  Ellipse1 [Al-Extruded] = ellipse(normal=Z, centre=(2mm, -1.5mm, 2mm), major_radius=1mm, ratio=1.5)
  all_2d_objects1 = component(all_2d_objects, 3D_Component_File_Path=D:/0temp/10_pyaedt_meshing_issue/all_2d_objects.a3dcomp)
  Rectangle1_1, Ellipse1_1 [Al-Extruded] = part_of(all_2d_objects1)
  all_3d_objects1 = component(all_3d_objects, 3D_Component_File_Path=D:/0temp/10_pyaedt_meshing_issue/all_3d_objects.a3dcomp)
  Box1_2, Cylinder1 [Al-Extruded] = part_of(all_3d_objects1)
  priority 2: Rectangle2, Ellipse1
  priority 2: Box1, Box2
  priority 1: IcepakDesign1_1
  priority 1: IcepakDesign1_1
boundaries and excitations:
  IcepakDesign1_1_Source1: Source Objects=Rectangle1 Thermal_Condition="Total Power" Total_Power=0.1W
mesh:
  MeshRegions:  Global{MeshMethod=MesherHD ComputeGap MeshRegionResolution=3 MinGapX=1mm MinGapY=1mm MinGapZ=1mm Objects=Region FacetLevel=3 ProximitySizeFunction CurvatureSizeFunction OptimizePCBMesh}
  MeshOperations:
