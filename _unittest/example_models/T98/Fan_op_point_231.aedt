# Ansys Electronics Desktop project, version 2023.1
project datasets:
  $ds1: (22, 1) (200, 0.6)
materials:
  AIR: permittivity=1 permeability=1 thermal_conductivity=0.0261 mass_density=1.1614 specific_heat=1005 thermal_expansion_coefficient=0.00333 thermal_material_type=Fluid diffusivity=2.88e-05 molecular_mass=0.028966 viscosity=1.84e-05
  Al-Extruded: thermal_conductivity=205 mass_density=2800 specific_heat=900 thermal_material_type=Solid
  BOTTOM_FILL: permittivity=4.5 permeability=1
  COPPER: thermal_modifier{Property=conductivity free_form_value=pwl($ds1,Temp)} conductivity=59590000 thermal_conductivity=387.6 mass_density=8933 specific_heat=397
  COPPER_1: conductivity=59590000 thermal_conductivity=387.6 mass_density=8933 specific_heat=397
  FR-4: permittivity=3.86 permeability=1 dielectric_loss_tangent=0.024 thermal_conductivity=0.35 mass_density=1250 specific_heat=1300
  FR-4_1: permittivity=4.5 permeability=1 dielectric_loss_tangent=0.035 thermal_conductivity=0.35 mass_density=1250 specific_heat=1300
  FR-4_2: permittivity=4.34 permeability=1 dielectric_loss_tangent=0.018 thermal_conductivity=0.35 mass_density=1250 specific_heat=1300
  FR-4_3: permittivity=3.86 permeability=1 dielectric_loss_tangent=0.024 thermal_conductivity=0.35 mass_density=1250 specific_heat=1300
  FR4_epoxy: permittivity=4.4 dielectric_loss_tangent=0.02 thermal_conductivity=0.294 mass_density=1900 specific_heat=1150 youngs_modulus=11000000000 poissons_ratio=0.28 thermal_expansion_coefficient=1.5e-05
  GND_FILL: permittivity=4.5 permeability=1 dielectric_loss_tangent=0.035
  LYR_1_FILL: permittivity=4.5 permeability=1 dielectric_loss_tangent=0.035
  LYR_2_FILL: permittivity=4.5 permeability=1 dielectric_loss_tangent=0.035
  pec: conductivity=1e+30
  PWR_FILL: permittivity=4.5 permeability=1 dielectric_loss_tangent=0.035
  solder: conductivity=7000000 thermal_conductivity=48 mass_density=8000 specific_heat=167 youngs_modulus=69000000000 poissons_ratio=0.4 thermal_expansion_coefficient=1.59e-06
  Teflon (tm): permittivity=2.1 dielectric_loss_tangent=0.001 thermal_conductivity=0.25 mass_density=2250 specific_heat=1400 youngs_modulus=496000000 poissons_ratio=0.3 thermal_expansion_coefficient=1.35e-06
  TOP_FILL: permittivity=4.5 permeability=1
  vacuum: permittivity=1
surface materials:
  Steel-oxidised-surface: surface_emissivity=0.8

design get_fan_op_point (Icepak, SteadyState TemperatureAndFlow, model units mm)
options: Default_Fluid_Material=air Default_Solid_Material=Al-Extruded Default_Surface_Material=Steel-oxidised-surface AmbientTemperature=20cel AmbientPressure=0n_per_meter_sq AmbientRadiationTemperature=20cel Gravity_Vector_CS_ID=Global Gravity_Vector_Axis=Z Positive=false Altitude=0meter
geometry:
  Region [air] = region(percentage_offset=50 on all sides)
  Fan_GHX2Y1_1 = component(Fan_GHX2Y1, Type=Fan Unit=mm ModelAs=3D Shape=Circular MovePlane=XY Radius=0.008mm HubRadius=0mm CaseSize=0.3mm CaseHeight=0.05mm CaseSide SheetID=43 BodyID=34 CaseID=6 FlowDirChoice=NormalPositive FlowType=Curve SwirlType=Magnitude SolidCaseMaterial=Al-Extruded SolidHubMaterial=Al-Extruded PassageMaterial=air DimUnits(m3_per_s, n_per_meter_sq) X(0, 0.01) Y(3, 0) Pressure_Loss_Curve{DimUnits(m_per_sec, n_per_meter_sq)} IntakeTemp=AmbientTemp Swirl=0 OperatingRPM=0 Magnitude=1)
  Fan_GHX2Y1_Case [Al-Extruded] = part_of(Fan_GHX2Y1_1)
  Fan_GHX2Y1_Passage [air] = part_of(Fan_GHX2Y1_1)
  Fan_GHX2Y1_Surface = part_of(Fan_GHX2Y1_1)
  Fan_6KGNGQ1 = component(Fan_6KGNGQ, Type=Fan Unit=mm ModelAs=3D Shape=Circular MovePlane=XY Radius=0.008mm HubRadius=0mm CaseSize=0.03mm CaseHeight=0.005mm CaseSide SheetID=43 BodyID=34 CaseID=6 FlowDirChoice=NormalPositive FlowType=Curve SwirlType=Magnitude SolidCaseMaterial=Al-Extruded SolidHubMaterial=Al-Extruded PassageMaterial=air DimUnits(m3_per_s, n_per_meter_sq) X(0, 0.01) Y(3, 0) Pressure_Loss_Curve{DimUnits(m_per_sec, n_per_meter_sq)} IntakeTemp=AmbientTemp Swirl=0 OperatingRPM=0 Magnitude=1)
  Fan_6KGNGQ_Case [Al-Extruded] = part_of(Fan_6KGNGQ1)
  Fan_6KGNGQ_Passage [air] = part_of(Fan_6KGNGQ1)
  Fan_6KGNGQ_Surface = part_of(Fan_6KGNGQ1)
  Fan_6KGNGQ1.move(TranslateVectorX=1mm TranslateVectorY=1mm TranslateVectorZ=1mm)
mesh:
  MeshRegions:  Global{MeshMethod=MesherHD ComputeGap MeshRegionResolution=3 MinGapX=1mm MinGapY=1mm MinGapZ=1mm Objects=Region FacetLevel=3 ProximitySizeFunction CurvatureSizeFunction OptimizePCBMesh}
  MeshOperations:
setups:
  test_setup: IcepakSteadyState Flow_Regime=Laminar Include_Temperature=true Include_Flow=true Convergence_Criteria_-_Flow=0.001 Convergence_Criteria_-_Energy=1e-07 disabled Radiation_Model=Off Under-relaxation_-_Pressure=0.7 Under-relaxation_-_Momentum=0.3 Under-relaxation_-_Temperature=1 Discretization_Scheme_-_Pressure=Standard Discretization_Scheme_-_Momentum=First Discretization_Scheme_-_Temperature=Second Convergence_Criteria_-_Max_Iterations=2

design get_fan_op_point1 (Icepak, Transient TemperatureAndFlow, model units mm)
options: Default_Fluid_Material=air Default_Solid_Material=Al-Extruded Default_Surface_Material=Steel-oxidised-surface AmbientTemperature=20cel AmbientPressure=0n_per_meter_sq AmbientRadiationTemperature=20cel Gravity_Vector_CS_ID=Global Gravity_Vector_Axis=Z Positive=false Altitude=0meter
geometry:
  Region [air] = region(percentage_offset=50 on all sides)
  Fan_NKGSQB1 = component(Fan_NKGSQB, Type=Fan Unit=mm ModelAs=3D Shape=Circular MovePlane=XY Radius=0.008mm HubRadius=0mm CaseSize=0.3mm CaseHeight=0.05mm CaseSide SheetID=43 BodyID=34 CaseID=6 FlowDirChoice=NormalPositive FlowType=Curve SwirlType=Magnitude SolidCaseMaterial=Al-Extruded SolidHubMaterial=Al-Extruded PassageMaterial=air DimUnits(m3_per_s, n_per_meter_sq) X(0, 0.01) Y(3, 0) Pressure_Loss_Curve{DimUnits(m_per_sec, n_per_meter_sq)} IntakeTemp=AmbientTemp Swirl=0 OperatingRPM=0 Magnitude=1)
  Fan_NKGSQB_Case [Al-Extruded] = part_of(Fan_NKGSQB1)
  Fan_NKGSQB_Passage [air] = part_of(Fan_NKGSQB1)
  Fan_NKGSQB_Surface = part_of(Fan_NKGSQB1)
  Fan_80JL21_1 = component(Fan_80JL21, Type=Fan Unit=mm ModelAs=3D Shape=Circular MovePlane=XY Radius=0.008mm HubRadius=0mm CaseSize=0.03mm CaseHeight=0.005mm CaseSide SheetID=43 BodyID=34 CaseID=6 FlowDirChoice=NormalPositive FlowType=Curve SwirlType=Magnitude SolidCaseMaterial=Al-Extruded SolidHubMaterial=Al-Extruded PassageMaterial=air DimUnits(m3_per_s, n_per_meter_sq) X(0, 0.01) Y(3, 0) Pressure_Loss_Curve{DimUnits(m_per_sec, n_per_meter_sq)} IntakeTemp=AmbientTemp Swirl=0 OperatingRPM=0 Magnitude=1)
  Fan_80JL21_Case [Al-Extruded] = part_of(Fan_80JL21_1)
  Fan_80JL21_Passage [air] = part_of(Fan_80JL21_1)
  Fan_80JL21_Surface = part_of(Fan_80JL21_1)
  Fan_80JL21_1.move(TranslateVectorX=1mm TranslateVectorY=1mm TranslateVectorZ=1mm)
mesh:
  MeshRegions:  Global{MeshMethod=MesherHD ComputeGap MeshRegionResolution=3 MinGapX=1mm MinGapY=1mm MinGapZ=1mm Objects=Region FacetLevel=3 ProximitySizeFunction CurvatureSizeFunction OptimizePCBMesh}
  MeshOperations:
setups:
  transient_setup: IcepakTransient Flow_Regime=Laminar Include_Temperature=true Include_Flow=true Convergence_Criteria_-_Flow=0.001 Convergence_Criteria_-_Energy=1e-07 disabled Radiation_Model=Off Under-relaxation_-_Pressure=0.3 Under-relaxation_-_Momentum=0.7 Under-relaxation_-_Temperature=1 Discretization_Scheme_-_Pressure=Standard Discretization_Scheme_-_Momentum=First Discretization_Scheme_-_Temperature=First Start_Time=0s Stop_Time=2s Time_Step=1s Iterations_per_Time_Step=20 SaveFieldsType="Every N Steps" N_Steps=10s
