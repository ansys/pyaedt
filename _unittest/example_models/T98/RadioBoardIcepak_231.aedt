# Ansys Electronics Desktop project, version 2023.1
project datasets:
  $ds1: (22, 1) (200, 0.6)
materials:
  COPPER: thermal_modifier{Property=conductivity free_form_value=pwl($ds1,Temp)} conductivity=59590000 thermal_conductivity=387.6 mass_density=8933 specific_heat=397
  COPPER_1: conductivity=59590000 thermal_conductivity=387.6 mass_density=8933 specific_heat=397
  FR-4: permittivity=3.86 permeability=1 dielectric_loss_tangent=0.024 thermal_conductivity=0.35 mass_density=1250 specific_heat=1300
  FR-4_1: permittivity=4.5 permeability=1 dielectric_loss_tangent=0.035 thermal_conductivity=0.35 mass_density=1250 specific_heat=1300
  FR-4_2: permittivity=4.34 permeability=1 dielectric_loss_tangent=0.018 thermal_conductivity=0.35 mass_density=1250 specific_heat=1300
  FR-4_3: permittivity=3.86 permeability=1 dielectric_loss_tangent=0.024 thermal_conductivity=0.35 mass_density=1250 specific_heat=1300
  Teflon (tm): permittivity=2.1 dielectric_loss_tangent=0.001 thermal_conductivity=0.25 mass_density=2250 specific_heat=1400 youngs_modulus=496000000 poissons_ratio=0.3 thermal_expansion_coefficient=1.35e-06
  AIR: permittivity=1 permeability=1 thermal_conductivity=0.0261 mass_density=1.1614 specific_heat=1005 thermal_expansion_coefficient=0.00333 thermal_material_type=Fluid diffusivity=2.88e-05 molecular_mass=0.028966 viscosity=1.84e-05
  vacuum: permittivity=1
  Al-Extruded: thermal_conductivity=205 mass_density=2800 specific_heat=900 thermal_material_type=Solid
surface materials:
  Steel-oxidised-surface: surface_emissivity=0.8

design IcepakDesign1 (Icepak, SteadyState TemperatureAndFlow, model units mm)
options: Default_Fluid_Material=air Default_Solid_Material=Al-Extruded Default_Surface_Material=Steel-oxidised-surface AmbientTemperature=amb AmbientPressure=0n_per_meter_sq AmbientRadiationTemperature=amb Gravity_Vector_CS_ID=Global Gravity_Vector_Axis=Z Positive=true Altitude=0meter
variables:
  amb = 25deg
geometry:
  Region [air] = region(percentage_offset=50 on all sides)
  coordinate_system RelativeCS1 = origin=(-1.71mm, -3.55mm, -15.47912mm) x=(1mm, 0mm, 0mm) y=(0mm, 1mm, 0mm)
  coordinate_system RelativeCS3 = origin=(-1.71mm, -3.55mm, -15.47912mm) x=(1mm, 0mm, 0mm) y=(0mm, 1mm, 0mm)
  coordinate_system RelativeCS2 = origin=(-1.71mm, -3.55mm, -15.47912mm) x=(1mm, 0mm, 0mm) y=(0mm, 1mm, 0mm)
  coordinate_system RelativeCS4 = origin=(-1.71mm, -3.55mm, -15.47912mm) x=(1mm, 0mm, 0mm) y=(0mm, 1mm, 0mm)
  coordinate_system RelativeCS5 = origin=(-1.71mm, -3.55mm, -15.47912mm) x=(1mm, 0mm, 0mm) y=(0mm, 1mm, 0mm)
  coordinate_system RelativeCS6 = origin=(-1.71mm, -3.55mm, -15.47912mm) x=(1mm, 0mm, 0mm) y=(0mm, 1mm, 0mm)
  coordinate_system RelativeCS7 = origin=(-1.71mm, -3.55mm, -15.47912mm) x=(1mm, 0mm, 0mm) y=(0mm, 1mm, 0mm)
  coordinate_system RelativeCS8 = origin=(-1.71mm, -3.55mm, -15.47912mm) x=(1mm, 0mm, 0mm) y=(0mm, 1mm, 0mm)
  coordinate_system RelativeCS9 = origin=(-1.71mm, -3.55mm, -15.47912mm) x=(1mm, 0mm, 0mm) y=(0mm, 1mm, 0mm)
  RadioBoard1_1 = component(RadioBoard1, Type=PCB Unit=mm MovePlane=XY ExtentsType="Bounding Box" PartsChoice=0 BBoxPolygon("cw=false", "cl=true", "pt(U='mm', x=33.5644, y=-3.80782, x=59.3228, y=-3.80782, x=59.3228, y=40.3217, x=33.5644, y=40.3217, x=33.5644, y=-3.80782)") EdbLayerInfoMap{oneLayerInfo{LayerIndex=1 LayerName=TOP LayerMaterial=COPPER Thickness=1.9mil LayerLowerElevation=0.00198628 LayerType=0 3D_Layout_Model_Unit=36} oneLayerInfo{LayerIndex=2 LayerName=UNNAMED_002 LayerMaterial=FR-4_3 Thickness=2.65mil LayerLowerElevation=0.00191897 LayerType=1 3D_Layout_Model_Unit=36} oneLayerInfo{LayerIndex=3 LayerName=PWR LayerMaterial=COPPER_1 Thickness=1.3mil LayerLowerElevation=0.00188595 LayerType=0 3D_Layout_Model_Unit=36} oneLayerInfo{LayerIndex=4 LayerName=UNNAMED_004 LayerMaterial=FR-4_2 Thickness=50mil LayerLowerElevation=0.00061595 LayerType=1 3D_Layout_Model_Unit=36} oneLayerInfo{LayerIndex=5 LayerName=LYR_1 LayerMaterial=COPPER_1 Thickness=1.2mil LayerLowerElevation=0.00058547 LayerType=0 3D_Layout_Model_Unit=36} oneLayerInfo{LayerIndex=6 LayerName=UNNAMED_006 LayerMaterial=FR-4_1 Thickness=8mil LayerLowerElevation=0.00038227 LayerType=1 3D_Layout_Model_Unit=36} oneLayerInfo{LayerIndex=7 LayerName=LYR_2 LayerMaterial=COPPER_1 Thickness=1.2mil LayerLowerElevation=0.00035179 LayerType=0 3D_Layout_Model_Unit=36} oneLayerInfo{LayerIndex=8 LayerName=UNNAMED_008 LayerMaterial=FR-4_1 Thickness=8mil LayerLowerElevation=0.00014859 LayerType=1 3D_Layout_Model_Unit=36} oneLayerInfo{LayerIndex=9 LayerName=GND Layer)
  RadioBoard1_011_BOTTOM_BBox, RadioBoard1_001_TOP_BBox [COPPER, surface Steel-Oxidised-surface] = part_of(RadioBoard1_1)
  RadioBoard1_002_UNNAMED_002_BBox [FR-4_3, surface Steel-Oxidised-surface] = part_of(RadioBoard1_1)
  RadioBoard1_003_PWR_BBox [COPPER_1, surface Steel-Oxidised-surface] = part_of(RadioBoard1_1)
  RadioBoard1_004_UNNAMED_004_BBox [FR-4_2, surface Steel-Oxidised-surface] = part_of(RadioBoard1_1)
  RadioBoard1_005_LYR_1_BBox [COPPER_1, surface Steel-Oxidised-surface] = part_of(RadioBoard1_1)
  RadioBoard1_006_UNNAMED_006_BBox [FR-4_1, surface Steel-Oxidised-surface] = part_of(RadioBoard1_1)
  RadioBoard1_007_LYR_2_BBox [COPPER_1, surface Steel-Oxidised-surface] = part_of(RadioBoard1_1)
  RadioBoard1_008_UNNAMED_008_BBox [FR-4_1, surface Steel-Oxidised-surface] = part_of(RadioBoard1_1)
  RadioBoard1_009_GND_BBox [COPPER_1, surface Steel-Oxidised-surface] = part_of(RadioBoard1_1)
  RadioBoard1_010_UNNAMED_010_BBox [FR-4, surface Steel-Oxidised-surface] = part_of(RadioBoard1_1)
  Rectangle3 = rectangle(corner=(1.42mm, 1.5mm, 3.4291458mm), x_size=0.715mm, y_size=-0.4mm)
  Rectangle3.delete()
  coordinate_system RelativeCS10 = origin=(-1.71mm, -3.55mm, -15.47912mm) x=(1mm, 0mm, 0mm) y=(0mm, 1mm, 0mm)
  point P1 = (59mm, 40mm, 0mm)
  Component_Region [air, non-model] = imported_body()
  USB_VCC, USB_ID, USB_GND, usb_N, usb_P, USB_Shiels [COPPER] = imported_body()
  USBmale_ObjectFromFace1 [Teflon (tm)] = imported_body()
  Rectangle1, Rectangle1_1..Rectangle1_4, Rectangle2, Rectangle3_1, Rectangle3_1_1, Rectangle3_1_2, Rectangle3_1_3, Rectangle4..Rectangle7 [vacuum] = imported_body()
  Box1 [non-model] = imported_body()
  group Group1 = USB_VCC, USB_ID, USB_GND, usb_N, usb_P, USB_Shiels, USBmale_ObjectFromFace1, Rectangle1, Rectangle1_1..Rectangle1_4, Rectangle2, Rectangle3_1, Rectangle3_1_1, Rectangle3_1_2, Rectangle3_1_3, Rectangle4..Rectangle7
boundaries and excitations:
  Opening1: Opening Faces=Region.face(all 6) Temperature=AmbientTemp External_Rad._Temperature=AmbientRadTemp Inlet_Type=Pressure Total_Pressure=AmbientPressure
  EMLoss_DRA9XA: EM Loss Objects=[USB_VCC, USB_ID, USB_GND, usb_N, usb_P, USB_Shiels, USBmale_ObjectFromFace1, Rectangle1, Rectangle1_1..Rectangle1_4, Rectangle2, Rectangle3_1, Rectangle3_1_1, Rectangle3_1_2, Rectangle3_1_3, Rectangle4..Rectangle7] LinkID=18 Project=C:\Users\jleonatt\AppData\Local\Temp\scratchWNF7AH\USB_Connector.aedt Design=uUSB ForceSourceToSolve PreservePartnerSoln PathRelativeTo=TargetProject Intrinsics(2.5GHz) SurfaceOnly(32417, 32711, 32873, 34155, 34377, 34599, 36531, 36552, 36571, 36590, 36609, 36628, 36648, 36669, 36687, 36705, 36723, 36742, 36761, 36780) LossMultiplier=1
mesh:
  MeshRegions:  Global{MeshMethod=MesherHD UserSpecifiedSettings ComputeGap MaxElementSizeX=0.42930667mm MaxElementSizeY=0.735492mm MaxElementSizeZ=0.101727mm MinElementsInGap=1 MinElementsOnEdge=1 MaxSizeRatio=2 EnableMLM EnforeMLMType=3D MaxLevels=0 BufferLayers=0 UniformMeshParametersType=Average MinGapX=0.042930667mm MinGapY=0.042930667mm MinGapZ=0.042930667mm Objects=Region FacetLevel=3 ProximitySizeFunction CurvatureSizeFunction OptimizePCBMesh} PCB_Region{MeshMethod=MesherHD UserSpecifiedSettings MaxElementSizeX=2mm MaxElementSizeY=2mm MaxElementSizeZ=0.5mm MinElementsInGap=3 MinElementsOnEdge=2 MaxSizeRatio=2 EnableMLM EnforeMLMType=3D MaxLevels=0 BufferLayers=0 UniformMeshParametersType=Average 2DMLMType=2DMLM_None MinGapX=1mm MinGapY=1mm MinGapZ=1mm Objects=Component_Region ProximitySizeFunction CurvatureSizeFunction OptimizePCBMesh} MeshRegion_NAWHVC{MeshMethod=MesherHD MeshRegionResolution=3 MinGapX=1mm MinGapY=1mm MinGapZ=1mm Objects=Box1 ProximitySizeFunction CurvatureSizeFunction OptimizePCBMesh}
  MeshOperations:  Icepak_E2EBCF_L_2{MaxLevel=2 MinLevel=2 Objects=USB_Shiels Local_Mesh_Parameters_Type="CAD Local Mesh Parameters" X_count=0 Y_count=0 Z_count=0 Facet_Level=0} MeshLevel_MYVM8Z{MaxLevel=2 MinLevel=2 Groups(32415) Local_Mesh_Parameters_Type="No Local Mesh Parameters"}
monitors:
  P1: Quantities(19) Points=#36815
setups:
  Setup1: IcepakSteadyState Flow_Regime=Laminar Include_Temperature=true Include_Flow=true Convergence_Criteria_-_Flow=0.001 Convergence_Criteria_-_Energy=1e-07 disabled Radiation_Model=Off Under-relaxation_-_Pressure=0.3 Under-relaxation_-_Momentum=0.7 Under-relaxation_-_Temperature=1 Discretization_Scheme_-_Pressure=Standard Discretization_Scheme_-_Momentum=First Discretization_Scheme_-_Temperature=First Convergence_Criteria_-_Max_Iterations=100
