# Ansys Electronics Desktop project, version 2021.1
materials:
  AIR: permittivity=1 permeability=1
  BOTTOM_FILL: permittivity=4.5 permeability=1
  COPPER: conductivity=59590000
  COPPER_1: conductivity=59590000
  FR-4: permittivity=3.86 permeability=1 dielectric_loss_tangent=0.024
  FR-4_1: permittivity=4.5 permeability=1 dielectric_loss_tangent=0.035
  FR-4_2: permittivity=4.34 permeability=1 dielectric_loss_tangent=0.018
  FR-4_3: permittivity=3.86 permeability=1 dielectric_loss_tangent=0.024
  FR4_epoxy: permittivity=4.4 dielectric_loss_tangent=0.02
  GND_FILL: permittivity=4.5 permeability=1 dielectric_loss_tangent=0.035
  LYR_1_FILL: permittivity=4.5 permeability=1 dielectric_loss_tangent=0.035
  LYR_2_FILL: permittivity=4.5 permeability=1 dielectric_loss_tangent=0.035
  myMaterial: permittivity=4.1 permeability=1 conductivity=100
  pec: conductivity=1e+30
  PWR_FILL: permittivity=4.5 permeability=1 dielectric_loss_tangent=0.035
  solder: conductivity=7000000
  TOP_FILL: permittivity=4.5 permeability=1
  vacuum: permittivity=1

design uUSB (HFSS, DrivenTerminal, model units mm)
options: Calculate_Lossy_Dielectrics Save_Adaptive_support_files
geometry:
  USB_VCC, USB_ID, USB_GND, usb_N, usb_P, USB_Shiels [copper] = imported_body(D:\_AEs\_Robert\MicroUSB\u_USB_n_PCB.sab)
  USBmale_ObjectFromFace1 [FR4_epoxy] = imported_body(D:\_AEs\_Robert\MicroUSB\u_USB_n_PCB.sab)
  coordinate_system RelativeCS1 = origin=(-1.71mm, -3.55mm, -15.47912mm) x=(1mm, 0mm, 0mm) y=(0mm, 1mm, 0mm)
  [USB_VCC, USB_ID, USB_GND, usb_N, usb_P].split(plane=XY, keep=PositiveOnly) in RelativeCS1
  Rectangle1 = rectangle(corner=(0mm, -0.125mm, -0.30555841mm), x_size=-0.3mm, y_size=0.25mm)
  Rectangle1_1..Rectangle1_4 = Rectangle1.duplicate_along_line(step=(0mm, 0.65mm, 0mm), total=5)
  [Rectangle1, Rectangle1_1..Rectangle1_4].move(0mm, 0mm, 0.1527792mm)
  Rectangle2 = rectangle(corner=(-0.3mm, -0.125mm, -0.25555841mm), y_size=2.85mm, z_size=-0.1mm)
  Rectangle2.move(0mm, 0mm, 0.1527792mm)
  Rectangle3 = rectangle(corner=(1.42mm, 1.5mm, 3.4291458mm), x_size=0.715mm, y_size=-0.4mm)
  Rectangle3_1 = Rectangle3.duplicate_along_line(step=(0mm, -0.65mm, 0mm), total=2)
  Rectangle3_1_1 = Rectangle3_1.duplicate_along_line(step=(0mm, -0.65mm, 0mm), total=2)
  Rectangle3_1_2 = Rectangle3_1.duplicate_along_line(step=(0mm, 1.3mm, 0mm), total=2)
  Rectangle3_1_3 = Rectangle3_1.duplicate_along_line(step=(0mm, 1.95mm, 0mm), total=2)
  Rectangle4 = rectangle(corner=(-0.3mm, -0.125mm, -0.2027792mm), y_size=-0.53964466mm, z_size=0.1mm)
  Rectangle5 = rectangle(corner=(-0.3mm, 2.725mm, -0.2027792mm), y_size=0.53964466mm, z_size=0.1mm)
  Rectangle6 = rectangle(corner=(-0.3mm, 3.2646447mm, -0.2027792mm), z_size=0.1mm, x_size=0.335mm)
  Rectangle7 = rectangle(corner=(-0.3mm, -0.66464466mm, -0.2027792mm), z_size=0.1mm, x_size=0.335mm)
  [Rectangle1, Rectangle1_1..Rectangle1_4, Rectangle2, Rectangle3, Rectangle3_1, Rectangle3_1_1, Rectangle3_1_2, Rectangle3_1_3, Rectangle4..Rectangle7].move(-1.86mm, -4.975mm, -15.173562mm)
  RadiatingSurface [vacuum] = region(absolute_offset=5.0161461mm on all sides)
  [USB_VCC, USB_ID, USB_GND, usb_N, usb_P, USB_Shiels, USBmale_ObjectFromFace1, Rectangle1, Rectangle1_1..Rectangle1_4, Rectangle2, Rectangle3, Rectangle3_1, Rectangle3_1_1, Rectangle3_1_2, Rectangle3_1_3, Rectangle4..Rectangle7].rotate(axis=Y, angle=90deg) in RelativeCS1
  [USB_VCC, USB_ID, USB_GND, usb_N, usb_P, USB_Shiels, USBmale_ObjectFromFace1, Rectangle1, Rectangle1_1..Rectangle1_4, Rectangle2, Rectangle3, Rectangle3_1, Rectangle3_1_1, Rectangle3_1_2, Rectangle3_1_3, Rectangle4..Rectangle7].rotate(axis=Y, angle=180deg)
  [USB_VCC, USB_ID, USB_GND, usb_N, usb_P, USB_Shiels, USBmale_ObjectFromFace1, Rectangle1, Rectangle1_1..Rectangle1_4, Rectangle2, Rectangle3, Rectangle3_1, Rectangle3_1_1, Rectangle3_1_2, Rectangle3_1_3, Rectangle4..Rectangle7].rotate(axis=Z, angle=90deg)
boundaries and excitations:
  PerfE1: Perfect E Objects=Rectangle2
  PerfE2: Perfect E Objects=[Rectangle1, Rectangle1_3, Rectangle1_4]
  PerfE3: Perfect E Objects=[Rectangle3_1_1, Rectangle3_1_2, Rectangle3_1_3]
  PerfE4: Perfect E Objects=[Rectangle5, Rectangle6, Rectangle4, Rectangle7]
  Open1: Radiation Objects=RadiatingSurface
  usb_N_pcb: Terminal port=N_pcb_Port Edges=Rectangle1_1.edge(4 of 4) TerminalResistance=50ohm
  usb_P_pcb: Terminal port=P_pcb_Port Edges=Rectangle1_2.edge(4 of 4) TerminalResistance=50ohm
  usb_P_conn: Terminal port=P_conn_Port Edges=?.edge(#1936) TerminalResistance=50ohm
  usb_N_conn: Terminal port=N_conn_Port Edges=?.edge(#1731) TerminalResistance=50ohm
  N_pcb_Port: Lumped Port Faces=Rectangle1_1.face(1 of 1) Impedance=50ohm
  P_pcb_Port: Lumped Port Faces=Rectangle1_2.face(1 of 1) Impedance=50ohm
  P_conn_Port: Lumped Port Faces=Rectangle3.face(#9157) Impedance=50ohm
  N_conn_Port: Lumped Port Faces=Rectangle3_1.face(1 of 1) Impedance=50ohm
  reference conductors: Rectangle2, USB_Shiels
setups:
  Setup1: HfssDriven Frequency=2GHz MaxDeltaS=0.02 MaximumPasses=10 MinimumPasses=1 MinimumConvergedPasses=1 PercentRefinement=30 BasisOrder=1 PortAccuracy=2
    sweep Sweep: 0GHz to 5GHz step 0.01GHz; Type=Interpolating InterpTolerance=0.5 InterpMaxSolns=250 MinSolvedFreq=0.01GHz PassivityErrorTolerance=0.0001
source amplitudes:
  N_pcb_Port:1: 1V 0deg
  P_pcb_Port:1, P_conn_Port:1, N_conn_Port:1: 0V 0deg
reports:
  XY Plot 1: dB(St(usb_N_pcb,usb_N_conn)) vs Freq on Setup1 : Sweep

design Galileo_G87173_204 (HFSS 3D Layout)
components:
  S54 = uUSB_L1()
  S57 = uUSB_L1()
nets:
  USBH2_DN_CH: port J3B2.2.USBH2_DN_CH, S54.usb_N_pcb
  USBH2_DP_CH: port J3B2.3.USBH2_DP_CH, S54.usb_P_pcb
  VBUS1: port J2B3-2, S57.usb_N_pcb
ports:
  J2B3-2: Properties{Reference=GND:GND:poly_512 Impedance=50ohm Magnitude=1V Phase=0deg Renormalize_Impedence="50ohm + 0i ohm" Renormalize Deembed_Distance=0mm Deembed Layer_Alignment=Upper Horizontal_Extent_Factor=5 Vertical_Extent_Factor=3 PEC_Launch_Width=0mm Reference_Net=GND} Type="Pad Port" Pin=J2B3-2 AutoPort Material=copper ViaMesh=Wirebond Sides=3
  J3B2.2.USBH2_DN_CH: Properties{Reference=PWR:V5_ALW_ON:poly_1489 Impedance=50ohm Magnitude=1V Phase=0deg Renormalize_Impedence="50ohm + 0i ohm" Renormalize Deembed_Distance=0mm Deembed Type="Pad Port Gap Source" HFSS_Type=Auto Orientation=Horizontal Layer_Alignment=Upper Horizontal_Extent_Factor=5 Vertical_Extent_Factor=3 PEC_Launch_Width=0mm Reference_Net=GND} Type="Pad Port" Pin=J3B2.2.USBH2_DN_CH AutoPort Material=copper ViaMesh=Wirebond Sides=3
  J3B2.3.USBH2_DP_CH: Properties{Reference=PWR:V5_ALW_ON:poly_1489 Impedance=50ohm Magnitude=1V Phase=0deg Renormalize_Impedence="50ohm + 0i ohm" Renormalize Deembed_Distance=0mm Deembed Type="Pad Port Gap Source" HFSS_Type=Auto Orientation=Horizontal Layer_Alignment=Upper Horizontal_Extent_Factor=5 Vertical_Extent_Factor=3 PEC_Launch_Width=0mm Reference_Net=GND} Type="Pad Port" Pin=J3B2.3.USBH2_DP_CH AutoPort Material=copper ViaMesh=Wirebond Sides=3
setups:
  HFSS Setup 1: SolveSetupType=HFSS PercentRefinementPerPass=30 MinNumberOfPasses=1 MinNumberOfConvergedPasses=1 Frequency=10GHz MeshSizeFactor=1.5 ViaNumSides=6 ViaMaterial=copper Style25DVia=Mesh
