# Ansys Electronics Desktop project, version 2022.1
materials:
  vacuum: permittivity=1
  PVC plastic: permittivity=2.7 dielectric_loss_tangent=0.007
  copper: permeability=0.999991 conductivity=58000000
  pec: conductivity=1e+30

design HFSSDesign1 (HFSS, DrivenModal, model units mm)
geometry:
  Rectangle1 = rectangle(corner=(-1000mm, -1000mm, -15mm), x_size=2000mm, y_size=2000mm)
  Polyline1 = polyline(z=0mm, xy in mm: (-800, -900) (-800, -500) (-200, -100) (500, 100) (700, 900), Spline from point 0 over 5)
  Region [vacuum] = region(percentage_offset=10 on all sides)
boundaries and excitations:
  PerfE1: Perfect E Objects=Rectangle1
  Rad1: Radiation Objects=Region
setups:
  Setup1: HfssDrivenAuto AutoSolverSetting=Balanced Type=Discrete
    sweep Sweep: 1Hz to 200Hz, 10 points;
field plots:
  Mag_E1: E Field over Rectangle1.face on Setup1 : LastAdaptive at Freq=1.005e-07GHz Phase=0deg
  Mag_E2: E Field over a plane on Setup1 : LastAdaptive at Freq=1.005e-07GHz Phase=0deg
