# Ansys Electronics Desktop project, version 2022.1
materials:
  vacuum: permittivity=1
  pec: conductivity=1e+30

design HFSSDesign1 (HFSS, SBR+, model units meter)
variables:
  plate1_x = 50cm
  plate2_x = -15cm
  plate2_y = 30cm
  src_x = 19.5cm
  src_y = 0cm
  p2_rot = 90deg
  src_rot = 180deg
geometry:
  coordinate_system plate_1 = origin=(-plate1_x, 0meter, 0meter) x=(0.01meter, 0meter, 0meter) y=(0meter, 0.01meter, 0meter)
  coordinate_system plate_2 = origin=(plate2_x, plate2_y, 0meter) x=(0.01meter, 0meter, 0meter) y=(0meter, 0.01meter, 0meter)
  coordinate_system source = origin=(src_x, src_y, 0meter) x=(0.01meter, 0meter, 0meter) y=(0meter, 0.01meter, 0meter)
  Tri_Plate_Config1 = component(Tri_Plate_Config, 3D_Component_File_Path=D:/Project_1_Time_Domain/Cases/DEMO4/Tri_Plate_Config.a3dcomp, w=10cm, l=60cm, indx=1, rot_1=45deg, rot_2=45deg)
  Right, Left, Center [pec] = part_of(Tri_Plate_Config1) in plate_1
  Tx1 = component(Tx, Type="Parametric Beam" Unit=cm Size=0.1cm Sheet=6 MatchedPortImpedance=50ohm Polarization=Vertical Representation="Far Field" Vertical_BeamWidth=20deg Horizontal_BeamWidth=60deg)
  Tx_Footprint [non-model] = part_of(Tx1) in source
  Tx1.rotate(RotateAxis=Z RotateAngle=src_rot) in source
  coordinate_system Near_Field = origin=(-0.15meter, 0meter, 0meter) x=(1meter, 0meter, 0meter) y=(0meter, 1meter, 0meter)
boundaries and excitations:
  Tri_Plate_Config1_SBRRegion1: Hybrid Region Objects=[Right, Left, Center] Type=SBR+
  Tri_Plate_Config1_PerfE1: Perfect E Objects=[Right, Left, Center]
  Tx1_p1: Proxy Port Objects=Tx_Footprint DefinitionPortType=-3 NumModes=1 RenormalizeAllTerminals=false Modes{Mode1{CharImp=Zpi}}
setups:
  Setup1: HfssDriven RayDensityPerWavelength=1 MaxNumberOfBounces=5 RadiationSetup=11 RadiationSetupIsNearField PTDUTDSimulationSettings="PTD Correction + UTD Rays" PTDEdgeDensity=20 ComputeFarFields
    sweep Sweep: 0.7GHz to 0.82GHz, 11 points;
source amplitudes:
  Tx1_p1:1: 1W 0deg
radiation setups:
  Near_Field: Near Rectangle  Length=1meter Width=1meter LengthSamples=11 WidthSamples=11 CoordSystem=Near_Field
reports:
  Near E Plot 1: dB(NearETotal) vs _u on Setup1 : Sweep [_v=all Freq=70GHz]
  Near E Plot 2: dB(NearETotal) vs _u, _v on Setup1 : Sweep [Freq=70GHz]
