# Ansys Electronics Desktop project, version 2023.1
materials:
  vacuum: permittivity=1
  copper: permeability=0.999991 conductivity=58000000
  FR4_epoxy: permittivity=4.4 dielectric_loss_tangent=0.02

design 2DExtractorDesign1 (2D Extractor, Open, model units mm)
options: LumpedLength=1meter RiseTime=1ns DistribLengthUnits=meter Calculate_Lossy_Dielectrics
geometry:
  Ellipse1, Circle1 [copper] = imported_body()
boundaries and excitations:
  Ellipse1: SignalLine Objects=Ellipse1 SolveOption=SolveInside Thickness=-1000mm
  Circle1: ReferenceGround Objects=Circle1 SolveOption=SolveInside Thickness=-1000mm
setups:
  Setup1: 2DMatrix AdaptiveFreq=0.1GHz SaveFields CGDataBlock{MaxPass=2 MinPass=1 MinConvPass=1 PerError=1 PerRefine=30 Included PerErrorParamConv=1} RLDataBlock{MaxPass=2 MinPass=1 MinConvPass=1 PerError=1 PerRefine=30 Included PerErrorParamConv=1}
source amplitudes:
  Ellipse1: CG Fields 1V 0deg
  Ellipse1: RL Fields 1A 0deg

design ViaModel (Q3D Extractor, model units mm)
options: Background_Material=FR4_epoxy SParamCalcMethod=EqTransLine
variables:
  viarad = 0.2mm
  padrad = 0.6mm
geometry:
  via, groundplane [copper] = imported_body()
boundaries and excitations:
  via: SignalNet Objects=via
  groundplane: SignalNet Objects=groundplane
  Source1: Source Faces=?.face(#74) TerminalType=ConstantVoltage Net=via
  Sink1: Sink Faces=?.face(#48) TerminalType=ConstantVoltage Net=via
setups:
  Setup1: Matrix AdaptiveFreq=10MHz SaveFields Cap{MaxPass=2 MinPass=1 MinConvPass=1 PerError=1 PerRefine=30 AutoIncreaseSolutionOrder SolutionOrder=Normal Solver_Type=Iterative} DC{SolveResOnly Cond{MaxPass=2 MinPass=1 MinConvPass=1 PerError=1 PerRefine=30} Mult{MaxPass=1 MinPass=1 MinConvPass=1 PerError=1 PerRefine=30} Solution_Order=Normal} AC{MaxPass=2 MinPass=1 MinConvPass=1 PerError=1 PerRefine=30} ErrorValue=0.1
source amplitudes:
  via:Source1: AC 1A
  groundplane: Cap 0V 0deg
  via: Cap 1V 0deg
  via:Source1: DC 1A
optimetrics:
  ParametricSetup1: Parametric Sim._Setups=[Setup1]
    sweep padrad: LIN 0.5mm 1.1mm 0.1mm
    table edits: del(1mm) del(0.8mm) del(0.6mm)
    calculate via_cap on Setup1 : LastAdaptive at Freq 100MHz to 0
output variables:
  via_cap = C(via,via)
field plots:
  SmoothQ1: Q on Setup1 : LastAdaptive at Freq=0.01GHz Phase=0deg
reports:
  XY Plot 2: C(via,via) vs padrad on Setup1 : LastAdaptive [viarad=all Freq=all]
  XY Plot 1: C(via,via) vs viarad on Setup1 : LastAdaptive [padrad=all Freq=all]
