# Ansys Electronics Desktop project, version 2024.2
materials:
  XG196/96: permeability{HUnit=A_per_meter BUnit=tesla curve (-690000, 0) (-663113.52, 0.048797862) (-635337.77, 0.097595724) (-606627.88, 0.14639359) (-576935.93, 0.19519145) (-546210.65, 0.24398931) (-514397.15, 0.29278717) (-481436.56, 0.34158503) (-447265.71, 0.39038289) (-411816.7, 0.43918076) (-375016.43, 0.48797862) (-333347.94, 0.54110533) (-291679.45, 0.5934675) (-250010.95, 0.64582967) (-208342.46, 0.69819184) (-166673.97, 0.75055402) (-125005.48, 0.80291619) (-83336.985, 0.85527836) (-41668.492, 0.90764053) (0, 0.96)}
  M19_24G: permeability{HUnit=A_per_meter BUnit=tesla curve (0, 0) (22.28, 0.05) (25.46, 0.1) (31.83, 0.15) (47.74, 0.36) (63.66, 0.54) (79.57, 0.65) (159.15, 0.99) (318.3, 1.2) (477.46, 1.28) (636.61, 1.33) (795.77, 1.36) (1591.5, 1.44) (3183, 1.52) (4774.6, 1.58) (6366.1, 1.63) (7957.7, 1.67) (15915, 1.8) (31830, 1.9) (111407, 2) (190984, 2.1) (350138, 2.3) (509292, 2.5)} conductivity=1960000 core_loss_type="Electrical Steel" core_loss_kh=164.2 core_loss_kc=1.3 core_loss_ke=1.72 mass_density=7650
  vacuum: permittivity=1
  M19_24G_2DSF0.950: permeability{HUnit=A_per_meter BUnit=tesla curve (0, 0) (22.28, 0.0475014) (25.46, 0.0950016) (31.83, 0.142502) (47.74, 0.342003) (63.66, 0.513004) (79.57, 0.617505) (159.15, 0.94051) (318.3, 1.14002) (477.46, 1.21603) (636.61, 1.26354) (795.77, 1.29205) (1591.5, 1.3681) (3183, 1.4442) (4774.6, 1.5013) (6366.1, 1.5489) (7957.7, 1.587) (15915, 1.711) (31830, 1.807) (111407, 1.907) (190984, 2.007) (350138, 2.207) (509292, 2.407) (2100830, 4.407)} conductivity=1960000 core_loss_type="Electrical Steel" core_loss_kh=172.842 core_loss_kc=1.36842 core_loss_ke=1.76468 mass_density=7267.5
  XG196/96_2DSF1.000_N: CoordinateSystemType=Cylindrical permeability=1 magnetic_coercivity{Magnitude=-726962A_per_meter DirComp1=1 DirComp2=0 DirComp3=0}
  XG196/96_2DSF1.000_S: CoordinateSystemType=Cylindrical permeability=1 magnetic_coercivity{Magnitude=-726962A_per_meter DirComp1=-1 DirComp2=0 DirComp3=0}
  copper: permeability=0.999991 conductivity=58000000 mass_density=8933
  M19_24G_3DSF0.950: permeability{HUnit=A_per_meter BUnit=tesla curve (0, 0) (22.28, 0.05) (25.46, 0.1) (31.83, 0.15) (47.74, 0.36) (63.66, 0.54) (79.57, 0.65) (159.15, 0.99) (318.3, 1.2) (477.46, 1.28) (636.61, 1.33) (795.77, 1.36) (1591.5, 1.44) (3183, 1.52) (4774.6, 1.58) (6366.1, 1.63) (7957.7, 1.67) (15915, 1.8) (31830, 1.9) (111407, 2) (190984, 2.1) (350138, 2.3) (509292, 2.5) (2100830, 4.5)} conductivity=1960000 core_loss_type="Electrical Steel" core_loss_kh=164.2 core_loss_kc=1.3 core_loss_ke=1.72 mass_density=7650 stacking_type=Lamination stacking_factor=0.95 stacking_direction=V(3)
  XG196/96_3DSF1.000_N: CoordinateSystemType=Cylindrical permeability=1 magnetic_coercivity{Magnitude=-726962A_per_meter DirComp1=1 DirComp2=0 DirComp3=0}
  XG196/96_3DSF1.000_S: CoordinateSystemType=Cylindrical permeability=1 magnetic_coercivity{Magnitude=-726962A_per_meter DirComp1=-1 DirComp2=0 DirComp3=0}

design assm-1 (RMxprt, Adjust-Speed Synchronous Machine, model units mm)
machine:
  Machine: FrictionLoss=12W WindLoss=0W ReferenceSpeed=1500rpm NumberOfPoles=4 RotorPosition=true ControlType=0 CircuitType=Y3
  Circuit: TriggerPulseWidth=120deg TransistorDrop=2V DiodeDrop=2V ModulationIndex=0 CarrierFrequencyTimes=0
  Stator: SkewWidth=0 NumberOfSlots=24 LaminationSectors=0 PressBoardThickness=0mm OuterDiameter=120mm InnerDiameter=75mm Length=65mm StackingFactor=0.95 SteelType=M19_24G SlotType=2
  Rotor: OuterDiameter=74mm InnerDiameter=26mm Length=65mm SteelType=M19_24G PoleType=1 StackingFactor=0.95
  Shaft:
  Stator Slot: Hs0=0.5mm Hs1=1mm Hs2=8.2mm Bs0=2.5mm Bs1=5.6mm Bs2=7.6mm Rs=0mm ToothWidth=0mm
  Stator Winding: WindingType=Whole-Coiled WindingLayers=2 ParallelBranches=1 ConductorsPerSlot=52 CoilPitch=5 EndAdjustment=0mm BaseInnerRadius=0mm TipInnerDiameter=0mm EndClearance=0mm CoilWrap=0mm SlotLiner=0.3mm WedgeThickness=0mm LayerInsulation=0mm BottomInsulation=0mm LimitedFillFactor=0.75 WdgNumberofPriodicMultipler=1 NumberOfStrands=1 WireWrap=0mm InterturnInsulation=0mm WireDiameter=0mm WireWidth=0mm WireThickness=0mm Gauge=AUTO
  Rotor Pole: Embrace=0.7 Offset=0mm ShaftDiameter=0mm Bridge=0mm Rib=0mm MagnetThickness=3.5mm MagnetWidth=0mm MagnetType=XG196/96
setups:
  Setup1: ASSM Motor RatedOutputPower=550W RatedVoltage=220V RatedSpeed=1500rpm OperatingTemperature=75cel LoadType=ConstPower RatedPowerFactor=0.75
