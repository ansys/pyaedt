# Ansys Electronics Desktop project, version 2024.1
materials:
  copper: conductivity=58000000
  FR4_epoxy: permittivity=4.4 dielectric_loss_tangent=0.02
  Megtron4: permittivity=3.77 dielectric_loss_tangent=0.005
  Megtron4_2: permittivity=3.47 dielectric_loss_tangent=0.006
  Megtron4_3: permittivity=4.2 dielectric_loss_tangent=0.005
  Solder Resist: permittivity=3
  solder: conductivity=7000000
  pec: conductivity=1e+30

design main (HFSS 3D Layout)
nets:
  PCIe_Gen4_TX3_CAP_N: port U1_PCIe_Gen4_TX3_CAP_N
  PCIe_Gen4_TX3_CAP_P: port U1_PCIe_Gen4_TX3_CAP_P
  PCIe_Gen4_TX3_N: port X1_PCIe_Gen4_TX3_N
  PCIe_Gen4_TX3_P: port X1_PCIe_Gen4_TX3_P
ports:
  U1_PCIe_Gen4_TX3_CAP_N: Properties{Impedance=50ohm Magnitude=0V Phase=0deg Renormalize_Impedence=50ohm Deembed_Distance=0mm Layer_Alignment=Upper Horizontal_Extent_Factor=5 Vertical_Extent_Factor=3 PEC_Launch_Width=0mm Reference_Net=GND} Type="Pad Port" Pin=U1_PCIe_Gen4_TX3_CAP_N
  U1_PCIe_Gen4_TX3_CAP_P: Properties{Impedance=50ohm Magnitude=0V Phase=0deg Renormalize_Impedence=50ohm Deembed_Distance=0mm Layer_Alignment=Upper Horizontal_Extent_Factor=5 Vertical_Extent_Factor=3 PEC_Launch_Width=0mm Reference_Net=GND} Type="Pad Port" Pin=U1_PCIe_Gen4_TX3_CAP_P
  X1_PCIe_Gen4_TX3_N: Properties{Impedance=50ohm Magnitude=0V Phase=0deg Renormalize_Impedence=50ohm Deembed_Distance=0mm Layer_Alignment=Upper Horizontal_Extent_Factor=5 Vertical_Extent_Factor=3 PEC_Launch_Width=0mm Reference_Net=GND} Type="Pad Port" Pin=X1_PCIe_Gen4_TX3_N
  X1_PCIe_Gen4_TX3_P: Properties{Impedance=50ohm Magnitude=0V Phase=0deg Renormalize_Impedence=50ohm Deembed_Distance=0mm Layer_Alignment=Upper Horizontal_Extent_Factor=5 Vertical_Extent_Factor=3 PEC_Launch_Width=0mm Reference_Net=GND} Type="Pad Port" Pin=X1_PCIe_Gen4_TX3_P
setups:
  setup1: SolveSetupType=SIwave
    sweep sweep_LDCWXG: 0GHz 1e-13GHz 1.2589254e-13GHz 1.5848932e-13GHz 1.9952623e-13GHz 2.5118864e-13GHz 3.1622777e-13GHz 3.9810717e-13GHz 5.0118723e-13GHz 6.3095734e-13GHz 7.9432823e-13GHz 1e-12GHz 1.2589254e-12GHz 1.5848932e-12GHz 1.9952623e-12GHz 2.5118864e-12GHz 3.1622777e-12GHz 3.9810717e-12GHz 5.0118723e-12GHz 6.3095734e-12GHz 7.9432823e-12GHz 1e-11GHz 1.2589254e-11GHz 1.5848932e-11GHz 1.9952623e-11GHz 2.5118864e-11GHz 3.1622777e-11GHz 3.9810717e-11GHz 5.0118723e-11GHz 6.3095734e-11GHz 7.9432823e-11GHz 1e-10GHz 1.2589254e-10GHz 1.5848932e-10GHz 1.9952623e-10GHz 2.5118864e-10GHz 3.1622777e-10GHz 3.9810717e-10GHz 5.0118723e-10GHz 6.3095734e-10GHz 7.9432823e-10GHz 1e-09GHz 1.2589254e-09GHz 1.5848932e-09GHz 1.9952623e-09GHz 2.5118864e-09GHz 3.1622777e-09GHz 3.9810717e-09GHz 5.0118723e-09GHz 6.3095734e-09GHz 7.9432823e-09GHz 1e-08GHz 1.2589254e-08GHz 1.5848932e-08GHz 1.9952623e-08GHz 2.5118864e-08GHz 3.1622777e-08GHz 3.9810717e-08GHz 5.0118723e-08GHz 6.3095734e-08GHz 7.9432823e-08GHz 1e-07GHz 1.2589254e-07GHz 1.5848932e-07GHz 1.9952623e-07GHz 2.5118864e-07GHz 3.1622777e-07GHz 3.9810717e-07GHz 5.0118723e-07GHz 6.3095734e-07GHz 7.9432823e-07GHz 1e-06GHz 1.2589254e-06GHz 1.5848932e-06GHz 1.9952623e-06GHz 2.5118864e-06GHz 3.1622777e-06GHz 3.9810717e-06GHz 5.0118723e-06GHz 6.3095734e-06GHz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;
reports:
  Plot_P4SRLZ: dB(S(PAIR_U1,PAIR_U1)) vs Freq on setup1 : sweep_LDCWXG
