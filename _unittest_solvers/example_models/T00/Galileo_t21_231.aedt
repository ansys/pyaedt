# Ansys Electronics Desktop project, version 2023.1
materials:
  AIR: permittivity=1 permeability=1
  BOTTOM_FILL: permittivity=4.5 permeability=1
  COPPER: conductivity=59590000
  COPPER_1: conductivity=59590000
  FR-4: permittivity=3.86 permeability=1 dielectric_loss_tangent=0.024
  FR-4_1: permittivity=4.5 permeability=1 dielectric_loss_tangent=0.035
  FR-4_2: permittivity=4.34 permeability=1 dielectric_loss_tangent=0.018
  FR-4_3: permittivity=3.86 permeability=1 dielectric_loss_tangent=0.024
  FR4_epoxy: permittivity=4.4 dielectric_loss_tangent=0.02
  GND_FILL: permittivity=4.5 permeability=1 dielectric_loss_tangent=0.035
  LYR_1_FILL: permittivity=4.5 permeability=1 dielectric_loss_tangent=0.035
  LYR_2_FILL: permittivity=4.5 permeability=1 dielectric_loss_tangent=0.035
  myMaterial: permittivity=4.1 permeability=1 conductivity=100
  pec: conductivity=1e+30
  PWR_FILL: permittivity=4.5 permeability=1 dielectric_loss_tangent=0.035
  solder: conductivity=7000000
  TOP_FILL: permittivity=4.5 permeability=1
  vacuum: permittivity=1

design uUSB (HFSS, HFSS Terminal Network, model units mm)
options: Calculate_Lossy_Dielectrics Save_Adaptive_support_files
geometry:
  coordinate_system RelativeCS1 = origin=(-1.71mm, -3.55mm, -15.47912mm) x=(1mm, 0mm, 0mm) y=(0mm, 1mm, 0mm)
  RadiatingSurface [vacuum] = region(absolute_offset=5.0161461mm on all sides)
  USB_VCC, USB_ID, USB_GND, usb_N, usb_P, USB_Shiels [copper] = imported_body()
  USBmale_ObjectFromFace1 [FR4_epoxy] = imported_body()
  Rectangle1, Rectangle1_1..Rectangle1_4, Rectangle2, Rectangle3, Rectangle3_1, Rectangle3_1_1, Rectangle3_1_2, Rectangle3_1_3, Rectangle4..Rectangle7 [vacuum] = imported_body()
boundaries and excitations:
  PerfE1: Perfect E Objects=Rectangle2
  PerfE2: Perfect E Objects=[Rectangle1, Rectangle1_3, Rectangle1_4]
  PerfE3: Perfect E Objects=[Rectangle3_1_1, Rectangle3_1_2, Rectangle3_1_3]
  PerfE4: Perfect E Objects=[Rectangle5, Rectangle6, Rectangle4, Rectangle7]
  Open1: Radiation Objects=RadiatingSurface
  usb_N_pcb: Terminal port=N_pcb_Port Edges=?.edge(#9091) TerminalResistance=50ohm
  usb_P_pcb: Terminal port=P_pcb_Port Edges=?.edge(#9103) TerminalResistance=50ohm
  usb_P_conn: Terminal port=P_conn_Port Edges=?.edge(#1936) TerminalResistance=50ohm
  usb_N_conn: Terminal port=N_conn_Port Edges=?.edge(#1731) TerminalResistance=50ohm
  N_pcb_Port: Lumped Port Faces=?.face(#9087) LumpedPortType=Terminal Impedance=50ohm
  P_pcb_Port: Lumped Port Faces=?.face(#9099) LumpedPortType=Terminal Impedance=50ohm
  P_conn_Port: Lumped Port Faces=?.face(#9157) LumpedPortType=Terminal Impedance=50ohm
  N_conn_Port: Lumped Port Faces=?.face(#9161) LumpedPortType=Terminal Impedance=50ohm
  reference conductors: Rectangle2, USB_Shiels
setups:
  Setup1: HfssDriven Frequency=2GHz MaxDeltaS=0.02 MaximumPasses=10 MinimumPasses=1 MinimumConvergedPasses=1 PercentRefinement=30 BasisOrder=1 PortAccuracy=2 DrivenSolverType="Direct Solver"
    sweep Sweep: 0GHz to 5GHz step 0.01GHz; Type=Interpolating InterpTolerance=0.5 InterpMaxSolns=250 MinSolvedFreq=0.01GHz PassivityErrorTolerance=0.0001
source amplitudes:
  N_pcb_Port:1: 1V 0deg
  P_pcb_Port:1, P_conn_Port:1, N_conn_Port:1: 0V 0deg
reports:
  XY Plot 1: dB(St(usb_N_pcb,usb_N_conn)) vs Freq on Setup1 : Sweep

design Galileo_G87173_204 (HFSS 3D Layout)
components:
  S54 = uUSB_L1()
  S57 = uUSB_L1()
nets:
  USBH2_DN_CH: port J3B2.2.USBH2_DN_CH, S54.usb_N_pcb
  USBH2_DP_CH: port J3B2.3.USBH2_DP_CH, S54.usb_P_pcb
  VBUS1: port J2B3-2, S57.usb_N_pcb
ports:
  J2B3-2: Properties{Reference=GND:GND:poly_512 Impedance=50ohm Magnitude=1V Phase=0deg Renormalize_Impedence="50ohm + 0i ohm" Renormalize Deembed_Distance=0mm Deembed Layer_Alignment=Upper Horizontal_Extent_Factor=5 Vertical_Extent_Factor=3 PEC_Launch_Width=0mm Reference_Net=GND} Type="Pad Port" Pin=J2B3-2 AutoPort Material=copper ViaMesh=Wirebond Sides=3
  J3B2.2.USBH2_DN_CH: Properties{Reference=PWR:V5_ALW_ON:poly_1489 Impedance=50ohm Magnitude=1V Phase=0deg Renormalize_Impedence="50ohm + 0i ohm" Renormalize Deembed_Distance=0mm Deembed Type="Pad Port Gap Source" HFSS_Type=Auto Orientation=Horizontal Layer_Alignment=Upper Horizontal_Extent_Factor=5 Vertical_Extent_Factor=3 PEC_Launch_Width=0mm Reference_Net=GND} Type="Pad Port" Pin=J3B2.2.USBH2_DN_CH AutoPort Material=copper ViaMesh=Wirebond Sides=3
  J3B2.3.USBH2_DP_CH: Properties{Reference=PWR:V5_ALW_ON:poly_1489 Impedance=50ohm Magnitude=1V Phase=0deg Renormalize_Impedence="50ohm + 0i ohm" Renormalize Deembed_Distance=0mm Deembed Type="Pad Port Gap Source" HFSS_Type=Auto Orientation=Horizontal Layer_Alignment=Upper Horizontal_Extent_Factor=5 Vertical_Extent_Factor=3 PEC_Launch_Width=0mm Reference_Net=GND} Type="Pad Port" Pin=J3B2.3.USBH2_DP_CH AutoPort Material=copper ViaMesh=Wirebond Sides=3
setups:
  HFSS Setup 1: SolveSetupType=HFSS PercentRefinementPerPass=30 MinNumberOfPasses=1 MinNumberOfConvergedPasses=1 Frequency=10GHz MeshSizeFactor=1.5 ViaNumSides=6 ViaMaterial=copper Style25DVia=Mesh
