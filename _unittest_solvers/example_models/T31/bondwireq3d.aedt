# Ansys Electronics Desktop project, version 2020.2
materials:
  vacuum: permittivity=1
  copper: permeability=0.999991 conductivity=58000000

design Q3DDesign1 (Q3D Extractor, model units mm)
options: SParamCalcMethod=EqTransLine Calculate_Lossy_Dielectrics
geometry:
  bondwire_example [copper, non-model] = imported_body(D:\work\Consultancy\ECL8233 01A.stp)
  bondwire_example.move(2750.8938mm, -92.515128mm, -215.63725mm)
  bondwire_example.move(0mm, 0mm, 0mm)
