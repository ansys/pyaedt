# Ansys Electronics Desktop project, version 2023.1
materials:
  vacuum: permittivity=1
  copper: permeability=0.999991 conductivity=58000000

design Terminal (HFSS, HFSS Terminal Network, model units mm)
geometry:
  Cylinder1 [copper] = imported_body()
  Cylinder2 [vacuum] = imported_body()
boundaries and excitations:
  Cylinder1_T1: Terminal port=1 Faces=?.face(#9) TerminalResistance=50ohm
  Cylinder1_T2: Terminal port=2 Faces=?.face(#8) TerminalResistance=50ohm
  1: Lumped Port Faces=?.face(#18) LumpedPortType=Terminal Impedance=50ohm
  2: Lumped Port Faces=?.face(#17) LumpedPortType=Terminal Impedance=50ohm
setups:
  Setup1: HfssDriven Frequency=1GHz MaxDeltaS=0.02 MaximumPasses=6 MinimumPasses=1 MinimumConvergedPasses=1 PercentRefinement=30 BasisOrder=1 PortAccuracy=2 DrivenSolverType="Direct Solver"
    sweep Sweep: 0.5GHz to 1.5GHz, 401 points; Type=Interpolating InterpTolerance=0.5 InterpMaxSolns=250 PassivityErrorTolerance=0.0001
  Setup2: HfssDriven Frequency=5GHz MaxDeltaS=0.02 MaximumPasses=6 MinimumPasses=1 MinimumConvergedPasses=1 PercentRefinement=30 BasisOrder=1 PortAccuracy=2 DrivenSolverType="Direct Solver"
    sweep Sweep: 2.5GHz to 7.5GHz, 401 points; Type=Interpolating InterpTolerance=0.5 InterpMaxSolns=250 InterpUseS=false
source amplitudes:
  1:1: 1V 0deg
  2:1: 0V 0deg

design 2DExtractorDesign1 (2D Extractor, Open, model units mm)
options: LumpedLength=1meter RiseTime=1ns DistribLengthUnits=meter Calculate_Lossy_Dielectrics
variables:
  r1 = 0.3mm
geometry:
  Circle1, Circle2, Circle3 [copper] = imported_body()
boundaries and excitations:
  Circle2: SignalLine Objects=Circle2 SolveOption=SolveInside Thickness=-1000mm
  Circle3: SignalLine Objects=Circle3 SolveOption=SolveInside Thickness=-1000mm
  Circle1: ReferenceGround Objects=Circle1 SolveOption=SolveInside Thickness=-1000mm
setups:
  Setup1: 2DMatrix AdaptiveFreq=1GHz SaveFields CGDataBlock{MaxPass=10 MinPass=1 MinConvPass=1 PerError=1 PerRefine=30 Included PerErrorParamConv=1} RLDataBlock{MaxPass=10 MinPass=1 MinConvPass=1 PerError=1 PerRefine=30 Included PerErrorParamConv=1}
    sweep Sweep1: 0Hz to 0Hz, 1 points; 1Hz to 1GHz, log, 10 per decade; 1GHz to 10GHz, log, 3 per decade; Type=Discrete
source amplitudes:
  Circle2: CG Fields 1V 0deg
  Circle3: CG Fields 0V 0deg
  Circle2: RL Fields 1A 0deg
  Circle3: RL Fields 0A 0deg

design Q3DDesign1 (Q3D Extractor, model units mm)
options: SParamCalcMethod=EqTransLine Calculate_Lossy_Dielectrics
geometry:
  Box1, Box1_1, Box1_2 [copper] = imported_body()
boundaries and excitations:
  Box1: SignalNet Objects=Box1
  Box1_1: SignalNet Objects=Box1_1
  Box1_2: SignalNet Objects=Box1_2
  Source1: Source Faces=?.face(#12) TerminalType=ConstantVoltage Net=Box1
  Source2: Source Faces=?.face(#41) TerminalType=ConstantVoltage Net=Box1_1
  Sink1: Sink Faces=?.face(#69) TerminalType=ConstantVoltage Net=Box1_2
  Sink2: Sink Faces=?.face(#10) TerminalType=ConstantVoltage Net=Box1
  Sink3: Sink Faces=?.face(#67) TerminalType=ConstantVoltage Net=Box1_2
  Sink4: Sink Faces=?.face(#39) TerminalType=ConstantVoltage Net=Box1_1
setups:
  Setup1: Matrix AdaptiveFreq=1GHz Cap{MaxPass=10 MinPass=1 MinConvPass=1 PerError=1 PerRefine=30 AutoIncreaseSolutionOrder SolutionOrder=High Solver_Type=Iterative} DC{Cond{MaxPass=10 MinPass=1 MinConvPass=1 PerError=1 PerRefine=30} Mult{MaxPass=1 MinPass=1 MinConvPass=1 PerError=1 PerRefine=30} Solution_Order=Normal} AC{MaxPass=10 MinPass=1 MinConvPass=1 PerError=1 PerRefine=30} ErrorValue=0.1
source amplitudes:
  Box1_1:Source2: AC 0A
  Box1:Source1: AC 1A
  Box1: Cap 1V 0deg
  Box1_1, Box1_2: Cap 0V 0deg
  Box1_1:Source2: DC 0A
  Box1:Source1: DC 1A
