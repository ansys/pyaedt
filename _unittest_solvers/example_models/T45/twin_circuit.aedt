# Ansys Electronics Desktop project, version 2024.1
materials:
  pec: conductivity=1e+30

design Simplorer1 (Twin Builder)
components:
  R2 = R()
nets:
  0: R2.0, R2.1
setups:
  TR: TransientData(40ms, 10.0us, 1.0ms, false, "")
